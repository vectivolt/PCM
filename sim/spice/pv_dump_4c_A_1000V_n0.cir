* PVCELL port-A terminal short, 4 cells, bank 1000 V, clamp 0 x WND75P16W6 (none), per-cell equivalent of the shared loop. Generated by sim/pv_design.py
.model dbody D(Is=4.014e-05 N=10.28 Rs=0.01567 Cjo=1.049e-09 Vj=3 M=0.5)
.model dcl D(Is=9.65e-21 N=1.16 Rs=3.1e+06 Cjo=0 Vj=0.7 M=0.5)
C1 c1 0 9e-05 ic=1000.0
Lesl c1 c2 9.5e-09
Resr c2 bp 0.00155
Lm bp m1 2e-06
Rm m1 0 0.0043408
Vsl 0 lx 0
Dlo lx l2 dbody m=2
Dhi l2 l1 dbody m=2
Lleg l1 bp 1.5e-08
.save v(c1) v(bp) i(Lm) i(Lesl) i(Vsl) v(l1)
.tran 1.38e-08 0.005529 0 2e-08 uic
.options method=gear maxord=2 reltol=2e-3 abstol=1e-6
.control
run
linearize v(c1) v(bp) i(Lm) i(Lesl) i(Vsl) v(l1)
wrdata pv_dump_4c_A_1000V_n0.dat v(c1) v(bp) i(Lm) i(Lesl) i(Vsl) v(l1)
quit
.endc
.end
