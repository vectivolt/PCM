* PVCELL commutation (double-pulse) test - Wolfspeed C3M0032120Kx2_3L_578V x2, 578 V, 72.4 A, L_loop 25.0 nH, R_G 1.4959555615255637 ohm per device. Generated by sim/pv_tradeoff.py
.model dut VDMOS(Vto=2.5 Kp=9.113 lambda=0.01 Rd=0.02222 Rs=0.5m Rg=1.7 Cgs=3.349e-09 Cgdmax=6.714e-10 Cgdmin=8e-12 a=0.0395 Cjo=2.212e-09 Vj=3 M=0.5 Is=7.58e-16 N=3 Rb=0.06338 Tt=0)
Vdc dcp 0 577.5
Rloop dcp dl 5m
Lloop dl dtop 2.5e-08
Rdamp dl dtop 10.0
Iload dtop mid 72.44999999999999
.model dsteer D(Is=1e-12 N=0.3)
.model dclamp D(Is=1e-6 N=1 Rs=0.05)
Rclh clh ghd 0.6
Mh0 dtop gh0 mid dut
Rgh0 ghd gh0 1.4959555615255637
Ml0 mid gl0 sl dut
Dcl0 gh0 clh dclamp
Rgl0 gld gl0 1.4959555615255637
Mh1 dtop gh1 mid dut
Rgh1 ghd gh1 1.4959555615255637
Ml1 mid gl1 sl dut
Dcl1 gh1 clh dclamp
Rgl1 gld gl1 1.4959555615255637
Vgh ghd mid -4.0
Vsense sl 0 0
Vgl gld 0 PULSE(-4.0 15.0 1e-07 5e-09 5e-09 1e-06 4u)
.save v(mid) v(dtop) v(gh0) i(Vsense) i(Lloop)
.tran 0.05n 1.7e-06 0 0.05n
.options method=gear maxord=2 reltol=2e-3 abstol=1e-9
.control
run
linearize v(mid) v(dtop) v(gh0) i(Vsense) i(Lloop)
wrdata pv_dpt_C3M0032120Kx2_3L_578V.dat v(mid) v(dtop) v(gh0) i(Vsense) i(Lloop)
quit
.endc
.end
