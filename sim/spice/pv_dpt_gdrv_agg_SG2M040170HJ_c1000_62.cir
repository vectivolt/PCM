* PVCELL commutation (double-pulse) test - Sichain gdrv_agg_SG2M040170HJ_c1000_62 x2, 1000 V, 62.4 A, L_loop 20.0 nH, R_G 4.5198433291323665 ohm per device. Generated by sim/pv_tradeoff.py
.model dut VDMOS(Vto=3.1 Kp=6.961 lambda=0.01 Rd=0.02936 Rs=0.5m Rg=1.4 Cgs=2.589e-09 Cgdmax=5.188e-10 Cgdmin=5e-12 a=0.05444 Cjo=2.098e-09 Vj=3 M=0.5 Is=7.58e-16 N=3 Rb=0.0143 Tt=0)
Vdc dcp 0 1000.0
Rsrc dcp bk 50m
Cbk bk bk1 9e-05
Lbk bk1 bk2 1.75e-08
Rbk bk2 0 0.002
Lbus bk lb 1.5e-08
Cdc lb dc1 6.6e-06
Ldc dc1 dc2 8.333333333333334e-09
Rdc dc2 0 0.00765
Lloop lb dtop 1.15e-08
Rdmp dtop dm 9.98
Cdmp dm 0 2.35e-09
Rdmpx dm 0 1e8
Iload dtop mid 62.41722276966296
.model dsteer D(Is=1e-12 N=0.3)
Rclh0 gh0 ghd 0.6
Rclh1 gh1 ghd 0.6
Mh0 dtop gx0 mid dut
Rgh0 ghd gh0 4.5198433291323665
Ml0 mid gl0 sl dut
Dgon0 gld gn0 dsteer
Rgon0 gn0 gl0 6.779764993698549
Dgof0 gf0 gld dsteer
Rgof0 gl0 gf0 4.5198433291323665
Mh1 dtop gh1 mid dut
Rgh1 ghd gh1 4.5198433291323665
Ml1 mid gl1 sl dut
Dgon1 gld gn1 dsteer
Rgon1 gn1 gl1 6.779764993698549
Dgof1 gf1 gld dsteer
Rgof1 gl1 gf1 4.5198433291323665
Vig0 gh0 gx0 0
Vgh ghd kh -3.5
Rksh kh mid 0.25
Vsense sl 0 0
Rksl kl sl 0.25
Vgl gld kl PULSE(-3.5 18.0 1e-07 5e-09 5e-09 1e-06 1)
.save v(mid) v(dtop) v(gh0) i(Vsense) i(Lloop) v(gx0) i(Vig0) v(dm) i(Ldc)
.tran 0.05n 1.7e-06 0 0.05n
.options method=gear maxord=2 reltol=5e-3 abstol=1e-8
.control
run
linearize v(mid) v(dtop) v(gh0) i(Vsense) i(Lloop) v(gx0) i(Vig0) v(dm) i(Ldc)
wrdata pv_dpt_gdrv_agg_SG2M040170HJ_c1000_62.dat v(mid) v(dtop) v(gh0) i(Vsense) i(Lloop) v(gx0) i(Vig0) v(dm) i(Ldc)
quit
.endc
.end
