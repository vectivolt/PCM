* DAB-D60 switching-level SPS deck "snub_ioffmax_rc_only" - generated by sim/dab_design.py, do not edit
* V1=750 V V2=600 V n=0.9167 L=6.500 uH Lm=150 uH phi=42.791 deg tdead=150 ns Ron=7.86 mohm
* snubber per bridge 6 x (6.8 ohm + 2.20 nF); HF ceramics none
.subckt sic d s g cq=1n
Bch d s I='(250*V(g)+1e-6)*tanh(V(d,s)/(0.00786*(250*V(g)+1e-6))) + V(d,s)*1e-8'
D1 s d dbody
Cq d s {cq}
.ends sic
.model dbody d(is=1e-9 n=5 rs=0.025)
Vp1 p1 0 DC 750
Vs1 p1 p1a 0
Rs1 p1a k1 1m
Rk1 k1 kr1 0.001033
Lk1 kr1 kc1 6.333e-09
Ck1 kc1 0 0.000135
Lb1 k1 bt1 7.2e-09
Lm1 bt1 bp1 1.5e-08
Rsn1 bt1 sn1 1.13333
Csn1 sn1 0 1.32e-08
XS1 bp1 na g1 sic cq=9.9108e-10
XS2 na 0 g2 sic cq=9.9108e-10
XS3 bp1 nb g2 sic cq=9.9108e-10
XS4 nb 0 g1 sic cq=9.9108e-10
Vil na na1 0
Lk na1 nx 6.5e-06 IC=-177.499
Lmag nx nb 0.00015 IC=-4.80836
Etr nx nxb nc nd 0.916667
Vtr nxb nb 0
Ftr nd nc Vtr 0.916667
Rg s0 0 1meg
Vp2 p2 s0 DC 600
Vs2 k2 p2a 0
Rs2 p2a p2 1m
Rk2 k2 kr2 0.0008667
Lk2 kr2 kc2 6.333e-09
Ck2 kc2 s0 0.000195
Lb2 k2 bt2 7.2e-09
Lm2 bt2 bp2 1.5e-08
Rsn2 bt2 sn2 1.13333
Csn2 sn2 s0 1.32e-08
XS5 bp2 nc g5 sic cq=1.1049e-09
XS6 nc s0 g6 sic cq=1.1049e-09
XS7 bp2 nd g6 sic cq=1.1049e-09
XS8 nd s0 g5 sic cq=1.1049e-09
Vg1 g1 0 PULSE(0 1 2e-07 2.5e-08 2.5e-08 4.824e-06 1e-05)
Vg2 g2 0 PULSE(1 0 5e-08 2.5e-08 2.5e-08 5.125e-06 1e-05)
Vg5 g5 0 PULSE(0 1 1.38863e-06 2.5e-08 2.5e-08 4.824e-06 1e-05)
Vg6 g6 0 PULSE(1 0 1.23863e-06 2.5e-08 2.5e-08 5.125e-06 1e-05)
.ic V(k1)=750 V(bt1)=750 V(bp1)=750 V(sn1)=750 V(p1a)=750 V(na)=0 V(nb)=750 V(k2)=600 V(bt2)=600 V(bp2)=600 V(sn2)=600 V(p2a)=600 V(nc)=0 V(nd)=600 V(nx)=200 V(kr1)=750 V(kc1)=750 V(kr2)=600 V(kc2)=600
.options method=gear reltol=1e-3 abstol=1e-6 vntol=1e-4 chgtol=1e-15 itl4=100
.tran 1e-09 0.00024 0.00019 1e-09 uic
.control
run
wrdata sim/out/dab_design/spice_snub_ioffmax_rc_only.txt i(Vil) V(na,nb) V(nc,nd) V(bp1,na) V(na) V(bp2,nc) V(nc) i(Vs1) i(Vs2) V(g1) V(g5) V(bp1) V(bt1,sn1) V(bt2,sn2) V(bp2,s0) V(bt1) V(bt2,s0)
quit
.endc
.end
