* PVCELL commutation (double-pulse) test - Microchip MSC035SMA170B4_cal x1, 1000 V, 50.0 A, L_loop 15.0 nH, R_G 4.3663343108858275 ohm per device. Generated by sim/pv_tradeoff.py
.model dut VDMOS(Vto=3.2 Kp=6.25 lambda=0.01 Rd=0.02448 Rs=0.5m Rg=0.85 Cgs=3.287e-09 Cgdmax=6.6e-10 Cgdmin=1.3e-11 a=0.07466 Cjo=2.596e-09 Vj=3 M=0.5 Is=7.58e-16 N=3 Rb=0.03121 Tt=0)
Vdc dcp 0 1000.0
Rloop dcp dl 5m
Lloop dl dtop 1.5e-08
Rdamp dl dtop 10.0
Iload dtop mid 50
.model dsteer D(Is=1e-12 N=0.3)
.model dclamp D(Is=1e-6 N=1 Rs=0.05)
Rclh clh ghd 0.6
Mh0 dtop gh0 mid dut
Rgh0 ghd gh0 4.3663343108858275
Ml0 mid gl0 sl dut
Dcl0 gh0 clh dclamp
Rgl0 gld gl0 4.3663343108858275
Vgh ghd mid -5.0
Vsense sl 0 0
Vgl gld 0 PULSE(-5.0 20.0 1e-07 5e-09 5e-09 1e-06 4u)
.save v(mid) v(dtop) v(gh0) i(Vsense) i(Lloop)
.tran 0.05n 1.7e-06 0 0.05n
.options method=gear maxord=2 reltol=2e-3 abstol=1e-9
.control
run
linearize v(mid) v(dtop) v(gh0) i(Vsense) i(Lloop)
wrdata pv_dpt_MSC035SMA170B4_cal.dat v(mid) v(dtop) v(gh0) i(Vsense) i(Lloop)
quit
.endc
.end
