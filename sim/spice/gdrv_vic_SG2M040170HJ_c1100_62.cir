* rev-5 gate network (N-MOSFET clamp per device), V_DS from the PV leg deck. Generated by sim/gdrv_miller.py
.model dut VDMOS(Vto=3.1 Kp=6.961 lambda=0.01 Rd=0.02936 Rs=0.5m Rg=1.4 Cgs=2.589e-09 Cgdmax=5.188e-10 Cgdmin=5e-12 a=0.05444 Cjo=2.098e-09 Vj=3 M=0.5 Is=7.58e-16 N=3 Rb=0.0143 Tt=0)
.model dbody D(Is=1e-12 N=1.5 Rs=0.05)
Vd dd 0 PWL(0.0000e+00 -3.41 2.0000e-10 -3.41 4.0000e-10 -3.41 6.0000e-10 -3.41 8.0000e-10 -3.41 1.0000e-09 -3.41 1.2000e-09 -3.41 1.4000e-09 -3.41 1.6000e-09 -3.41 1.8000e-09 -3.41 2.0000e-09 -3.41 2.2000e-09 -3.41 2.4000e-09 -3.41 2.6000e-09 -3.41 2.8000e-09 -3.41 3.0000e-09 -3.41 3.2000e-09 -3.41 3.4000e-09 -3.41 3.6000e-09 -3.41 3.8000e-09 -3.41 4.0000e-09 -3.41 4.2000e-09 -3.41 4.4000e-09 -3.41 4.6000e-09 -3.41 4.8000e-09 -3.41 5.0000e-09 -3.41 5.2000e-09 -3.41 5.4000e-09 -3.41 5.6000e-09 -3.41 5.8000e-09 -3.41 6.0000e-09 -3.41 6.2000e-09 -3.41 6.4000e-09 -3.41 6.6000e-09 -3.41 6.8000e-09 -3.41 7.0000e-09 -3.41 7.2000e-09 -3.41 7.4000e-09 -3.41 7.6000e-09 -3.41 7.8000e-09 -3.41 8.0000e-09 -3.41 8.2000e-09 -3.41 8.4000e-09 -3.41 8.6000e-09 -3.41 8.8000e-09 -3.41 9.0000e-09 -3.41 9.2000e-09 -3.41 9.4000e-09 -3.41 9.6000e-09 -3.41 9.8000e-09 -3.41 1.0000e-08 -3.41 1.0200e-08 -3.41 1.0400e-08 -3.41 1.0600e-08 -3.41 1.0800e-08 -3.41 1.1000e-08 -3.41 1.1200e-08 -3.41 1.1400e-08 -3.41 1.1600e-08 -3.41 1.1800e-08 -3.41 1.2000e-08 -3.41 1.2200e-08 -3.41 1.2400e-08 -3.41 1.2600e-08 -3.41 1.2800e-08 -3.41 1.3000e-08 -3.41 1.3200e-08 -3.41 1.3400e-08 -3.41 1.3600e-08 -3.41 1.3800e-08 -3.41 1.4000e-08 -3.41 1.4200e-08 -3.41 1.4400e-08 -3.41 1.4600e-08 -3.41 1.4800e-08 -3.41 1.5000e-08 -3.41 1.5200e-08 -3.41 1.5400e-08 -3.41 1.5600e-08 -3.41 1.5800e-08 -3.41 1.6000e-08 -3.41 1.6200e-08 -3.41 1.6400e-08 -3.41 1.6600e-08 -3.40 1.6800e-08 -3.39 1.7000e-08 -3.38 1.7200e-08 -3.36 1.7400e-08 -3.33 1.7600e-08 -3.31 1.7800e-08 -3.27 1.8000e-08 -3.24 1.8200e-08 -3.21 1.8400e-08 -3.17 1.8600e-08 -3.12 1.8800e-08 -3.08 1.9000e-08 -3.03 1.9200e-08 -2.97 1.9400e-08 -2.91 1.9600e-08 -2.83 1.9800e-08 -2.72 2.0000e-08 -2.56 2.0200e-08 -2.29 2.0400e-08 -1.86 2.0600e-08 -1.19 2.0800e-08 -0.15 2.1000e-08 1.38 2.1200e-08 3.58 2.1400e-08 6.63 2.1600e-08 10.73 2.1800e-08 16.15 2.2000e-08 23.21 2.2200e-08 32.26 2.2400e-08 43.71 2.2600e-08 57.98 2.2800e-08 75.48 2.3000e-08 96.61 2.3200e-08 121.69 2.3400e-08 151.03 2.3600e-08 184.81 2.3800e-08 223.13 2.4000e-08 265.98 2.4200e-08 313.24 2.4400e-08 364.64 2.4600e-08 419.82 2.4800e-08 478.27 2.5000e-08 539.40 2.5200e-08 602.53 2.5400e-08 666.92 2.5600e-08 731.79 2.5800e-08 796.37 2.6000e-08 859.85 2.6200e-08 921.48 2.6400e-08 980.60 2.6600e-08 1036.58 2.6800e-08 1088.90 2.7000e-08 1137.13 2.7200e-08 1180.93 2.7400e-08 1220.08 2.7600e-08 1254.44 2.7800e-08 1283.97 2.8000e-08 1308.72 2.8200e-08 1328.78 2.8400e-08 1344.34 2.8600e-08 1355.64 2.8800e-08 1362.93 2.9000e-08 1366.52 2.9200e-08 1366.73 2.9400e-08 1363.90 2.9600e-08 1358.36 2.9800e-08 1350.45 3.0000e-08 1340.51 3.0200e-08 1328.84 3.0400e-08 1315.76 3.0600e-08 1301.54 3.0800e-08 1286.46 3.1000e-08 1270.76 3.1200e-08 1254.66 3.1400e-08 1238.36 3.1600e-08 1222.06 3.1800e-08 1205.90 3.2000e-08 1190.04 3.2200e-08 1174.59 3.2400e-08 1159.66 3.2600e-08 1145.35 3.2800e-08 1131.72 3.3000e-08 1118.84 3.3200e-08 1106.75 3.3400e-08 1095.50 3.3600e-08 1085.11 3.3800e-08 1075.59 3.4000e-08 1066.96 3.4200e-08 1059.21 3.4400e-08 1052.35 3.4600e-08 1046.35 3.4800e-08 1041.19 3.5000e-08 1036.87 3.5200e-08 1033.34 3.5400e-08 1030.58 3.5600e-08 1028.56 3.5800e-08 1027.23 3.6000e-08 1026.56 3.6200e-08 1026.51 3.6400e-08 1027.04 3.6600e-08 1028.09 3.6800e-08 1029.63 3.7000e-08 1031.61 3.7200e-08 1033.99 3.7400e-08 1036.72 3.7600e-08 1039.76 3.7800e-08 1043.06 3.8000e-08 1046.57 3.8200e-08 1050.26 3.8400e-08 1054.09 3.8600e-08 1058.02 3.8800e-08 1062.01 3.9000e-08 1066.02 3.9200e-08 1070.03 3.9400e-08 1074.00 3.9600e-08 1077.89 3.9800e-08 1081.67 4.0000e-08 1085.31 4.0200e-08 1088.77 4.0400e-08 1092.04 4.0600e-08 1095.11 4.0800e-08 1097.96 4.1000e-08 1100.58 4.1200e-08 1102.98 4.1400e-08 1105.13 4.1600e-08 1107.06 4.1800e-08 1108.74 4.2000e-08 1110.20 4.2200e-08 1111.43 4.2400e-08 1112.44 4.2600e-08 1113.25 4.2800e-08 1113.85 4.3000e-08 1114.26 4.3200e-08 1114.50 4.3400e-08 1114.57 4.3600e-08 1114.49 4.3800e-08 1114.27 4.4000e-08 1113.92 4.4200e-08 1113.46 4.4400e-08 1112.91 4.4600e-08 1112.26 4.4800e-08 1111.55 4.5000e-08 1110.77 4.5200e-08 1109.94 4.5400e-08 1109.08 4.5600e-08 1108.19 4.5800e-08 1107.29 4.6000e-08 1106.37 4.6200e-08 1105.46 4.6400e-08 1104.56 4.6600e-08 1103.68 4.6800e-08 1102.82 4.7000e-08 1101.99 4.7200e-08 1101.19 4.7400e-08 1100.43 4.7600e-08 1099.72 4.7800e-08 1099.05 4.8000e-08 1098.42 4.8200e-08 1097.85 4.8400e-08 1097.32 4.8600e-08 1096.85 4.8800e-08 1096.42 4.9000e-08 1096.05 4.9200e-08 1095.73 4.9400e-08 1095.45 4.9600e-08 1095.22 4.9800e-08 1095.04 5.0000e-08 1094.90 5.0200e-08 1094.80 5.0400e-08 1094.74 5.0600e-08 1094.72 5.0800e-08 1094.72 5.1000e-08 1094.76 5.1200e-08 1094.83 5.1400e-08 1094.92 5.1600e-08 1095.03 5.1800e-08 1095.17 5.2000e-08 1095.31 5.2200e-08 1095.48 5.2400e-08 1095.65 5.2600e-08 1095.83 5.2800e-08 1096.02 5.3000e-08 1096.21 5.3200e-08 1096.41 5.3400e-08 1096.60 5.3600e-08 1096.80 5.3800e-08 1096.99 5.4000e-08 1097.18 5.4200e-08 1097.36 5.4400e-08 1097.53 5.4600e-08 1097.69 5.4800e-08 1097.85 5.5000e-08 1098.00 5.5200e-08 1098.14 5.5400e-08 1098.26 5.5600e-08 1098.38 5.5800e-08 1098.48 5.6000e-08 1098.58 5.6200e-08 1098.66 5.6400e-08 1098.73 5.6600e-08 1098.79 5.6800e-08 1098.84 5.7000e-08 1098.89 5.7200e-08 1098.92 5.7400e-08 1098.94 5.7600e-08 1098.95 5.7800e-08 1098.96 5.8000e-08 1098.96 5.8200e-08 1098.95 5.8400e-08 1098.94 5.8600e-08 1098.92 5.8800e-08 1098.89 5.9000e-08 1098.87 5.9200e-08 1098.83 5.9400e-08 1098.80 5.9600e-08 1098.76 5.9800e-08 1098.72 6.0000e-08 1098.68 6.0200e-08 1098.63 6.0400e-08 1098.59 6.0600e-08 1098.55 6.0800e-08 1098.50 6.1000e-08 1098.46 6.1200e-08 1098.42 6.1400e-08 1098.38 6.1600e-08 1098.34 6.1800e-08 1098.30 6.2000e-08 1098.26 6.2200e-08 1098.23 6.2400e-08 1098.20 6.2600e-08 1098.17 6.2800e-08 1098.14 6.3000e-08 1098.11 6.3200e-08 1098.09 6.3400e-08 1098.07 6.3600e-08 1098.05 6.3800e-08 1098.04 6.4000e-08 1098.02 6.4200e-08 1098.01 6.4400e-08 1098.00 6.4600e-08 1098.00 6.4800e-08 1097.99 6.5000e-08 1097.99 6.5200e-08 1097.98 6.5400e-08 1097.98 6.5600e-08 1097.98 6.5800e-08 1097.99 6.6000e-08 1097.99 6.6200e-08 1097.99 6.6400e-08 1098.00 6.6600e-08 1098.00 6.6800e-08 1098.01 6.7000e-08 1098.02 6.7200e-08 1098.02 6.7400e-08 1098.03 6.7600e-08 1098.04 6.7800e-08 1098.05 6.8000e-08 1098.05 6.8200e-08 1098.06 6.8400e-08 1098.07 6.8600e-08 1098.08 6.8800e-08 1098.08 6.9000e-08 1098.09 6.9200e-08 1098.10 6.9400e-08 1098.10 6.9600e-08 1098.11 6.9800e-08 1098.11 7.0000e-08 1098.12 7.0200e-08 1098.12 7.0400e-08 1098.12 7.0600e-08 1098.13 7.0800e-08 1098.13 7.1000e-08 1098.13 7.1200e-08 1098.13 7.1400e-08 1098.13 7.1600e-08 1098.13 7.1800e-08 1098.13 7.2000e-08 1098.13 7.2200e-08 1098.13 7.2400e-08 1098.13 7.2600e-08 1098.13 7.2800e-08 1098.13 7.3000e-08 1098.12 7.3200e-08 1098.12 7.3400e-08 1098.12 7.3600e-08 1098.12 7.3800e-08 1098.11 7.4000e-08 1098.11 7.4200e-08 1098.11 7.4400e-08 1098.11 7.4600e-08 1098.10 7.4800e-08 1098.10 7.5000e-08 1098.10 7.5200e-08 1098.09 7.5400e-08 1098.09 7.5600e-08 1098.09 7.5800e-08 1098.08 7.6000e-08 1098.08 7.6200e-08 1098.08 7.6400e-08 1098.07 7.6600e-08 1098.07 7.6800e-08 1098.07 7.7000e-08 1098.06 7.7200e-08 1098.06 7.7400e-08 1098.06 7.7600e-08 1098.06 7.7800e-08 1098.06 7.8000e-08 1098.05 7.8200e-08 1098.05 7.8400e-08 1098.05 7.8600e-08 1098.05 7.8800e-08 1098.05 7.9000e-08 1098.04 7.9200e-08 1098.04 7.9400e-08 1098.04 7.9600e-08 1098.04 7.9800e-08 1098.04 8.0000e-08 1098.04 8.0200e-08 1098.04 8.0400e-08 1098.04 8.0600e-08 1098.03 8.0800e-08 1098.03 8.1000e-08 1098.03 8.1200e-08 1098.03 8.1400e-08 1098.03 8.1600e-08 1098.03 8.1800e-08 1098.03 8.2000e-08 1098.03 8.2200e-08 1098.03 8.2400e-08 1098.03 8.2600e-08 1098.03 8.2800e-08 1098.03 8.3000e-08 1098.03 8.3200e-08 1098.02 8.3400e-08 1098.02 8.3600e-08 1098.02 8.3800e-08 1098.02 8.4000e-08 1098.02 8.4200e-08 1098.02 8.4400e-08 1098.02 8.4600e-08 1098.02 8.4800e-08 1098.02 8.5000e-08 1098.02 8.5200e-08 1098.02 8.5400e-08 1098.02 8.5600e-08 1098.01 8.5800e-08 1098.01 8.6000e-08 1098.01 8.6200e-08 1098.01 8.6400e-08 1098.01 8.6600e-08 1098.01 8.6800e-08 1098.01 8.7000e-08 1098.01 8.7200e-08 1098.01 8.7400e-08 1098.00 8.7600e-08 1098.00 8.7800e-08 1098.00 8.8000e-08 1098.00 8.8200e-08 1098.00 8.8400e-08 1098.00 8.8600e-08 1098.00 8.8800e-08 1098.00 8.9000e-08 1098.00 8.9200e-08 1097.99 8.9400e-08 1097.99 8.9600e-08 1097.99 8.9800e-08 1097.99 9.0000e-08 1097.99 9.0200e-08 1097.99 9.0400e-08 1097.99 9.0600e-08 1097.99 9.0800e-08 1097.99 9.1000e-08 1097.98 9.1200e-08 1097.98 9.1400e-08 1097.98 9.1600e-08 1097.98 9.1800e-08 1097.98 9.2000e-08 1097.98 9.2200e-08 1097.98 9.2400e-08 1097.98 9.2600e-08 1097.98 9.2800e-08 1097.97 9.3000e-08 1097.97 9.3200e-08 1097.97 9.3400e-08 1097.97 9.3600e-08 1097.97 9.3800e-08 1097.97 9.4000e-08 1097.97 9.4200e-08 1097.97 9.4400e-08 1097.97 9.4600e-08 1097.97 9.4800e-08 1097.97 9.5000e-08 1097.96 9.5200e-08 1097.96 9.5400e-08 1097.96 9.5600e-08 1097.96 9.5800e-08 1097.96 9.6000e-08 1097.96 9.6200e-08 1097.96 9.6400e-08 1097.96 9.6600e-08 1097.96 9.6800e-08 1097.96 9.7000e-08 1097.95 9.7200e-08 1097.95 9.7400e-08 1097.95 9.7600e-08 1097.95 9.7800e-08 1097.95 9.8000e-08 1097.95 9.8200e-08 1097.95 9.8400e-08 1097.95 9.8600e-08 1097.95 9.8800e-08 1097.95 9.9000e-08 1097.95 9.9200e-08 1097.94 9.9400e-08 1097.94 9.9600e-08 1097.94 9.9800e-08 1097.94 1.0000e-07 1097.94 1.0020e-07 1097.94 1.0040e-07 1097.94 1.0060e-07 1097.94 1.0080e-07 1097.94 1.0100e-07 1097.94 1.0120e-07 1097.94 1.0140e-07 1097.94 1.0160e-07 1097.93 1.0180e-07 1097.93 1.0200e-07 1097.93 1.0220e-07 1097.93 1.0240e-07 1097.93 1.0260e-07 1097.93 1.0280e-07 1097.93 1.0300e-07 1097.93 1.0320e-07 1097.93 1.0340e-07 1097.93 1.0360e-07 1097.93 1.0380e-07 1097.92 1.0400e-07 1097.92 1.0420e-07 1097.92 1.0440e-07 1097.92 1.0460e-07 1097.92 1.0480e-07 1097.92 1.0500e-07 1097.92 1.0520e-07 1097.92 1.0540e-07 1097.92 1.0560e-07 1097.92 1.0580e-07 1097.92 1.0600e-07 1097.92 1.0620e-07 1097.91 1.0640e-07 1097.91 1.0660e-07 1097.91 1.0680e-07 1097.91 1.0700e-07 1097.91 1.0720e-07 1097.91 1.0740e-07 1097.91 1.0760e-07 1097.91 1.0780e-07 1097.91 1.0800e-07 1097.91 1.0820e-07 1097.91 1.0840e-07 1097.91 1.0860e-07 1097.90 1.0880e-07 1097.90 1.0900e-07 1097.90 1.0920e-07 1097.90 1.0940e-07 1097.90 1.0960e-07 1097.90 1.0980e-07 1097.90 1.1000e-07 1097.90 1.1020e-07 1097.90 1.1040e-07 1097.90 1.1060e-07 1097.90 1.1080e-07 1097.90 1.1100e-07 1097.89 1.1120e-07 1097.89 1.1140e-07 1097.89 1.1160e-07 1097.89 1.1180e-07 1097.89 1.1200e-07 1097.89 1.1220e-07 1097.89 1.1240e-07 1097.89 1.1260e-07 1097.89 1.1280e-07 1097.89 1.1300e-07 1097.89 1.1320e-07 1097.89 1.1340e-07 1097.88 1.1360e-07 1097.88 1.1380e-07 1097.88 1.1400e-07 1097.88 1.1420e-07 1097.88 1.1440e-07 1097.88 1.1460e-07 1097.88 1.1480e-07 1097.88 1.1500e-07 1097.88 1.1520e-07 1097.88 1.1540e-07 1097.88 1.1560e-07 1097.88 1.1580e-07 1097.88 1.1600e-07 1097.87 1.1620e-07 1097.87 1.1640e-07 1097.87 1.1660e-07 1097.87 1.1680e-07 1097.87 1.1700e-07 1097.87 1.1720e-07 1097.87 1.1740e-07 1097.87 1.1760e-07 1097.87 1.1780e-07 1097.87 1.1800e-07 1097.87 1.1820e-07 1097.87 1.1840e-07 1097.87 1.1860e-07 1097.86 1.1880e-07 1097.86 1.1900e-07 1097.86 1.1920e-07 1097.86 1.1940e-07 1097.86 1.1960e-07 1097.86 1.1980e-07 1097.86 1.2000e-07 1097.86 1.2020e-07 1097.86 1.2040e-07 1097.86 1.2060e-07 1097.86 1.2080e-07 1097.86 1.2100e-07 1097.86 1.2120e-07 1097.85 1.2140e-07 1097.85 1.2160e-07 1097.85 1.2180e-07 1097.85 1.2200e-07 1097.85 1.2220e-07 1097.85 1.2240e-07 1097.85 1.2260e-07 1097.85 1.2280e-07 1097.85 1.2300e-07 1097.85 1.2320e-07 1097.85 1.2340e-07 1097.85 1.2360e-07 1097.85 1.2380e-07 1097.84 1.2400e-07 1097.84 1.2420e-07 1097.84 1.2440e-07 1097.84 1.2460e-07 1097.84 1.2480e-07 1097.84 1.2500e-07 1097.84 1.2520e-07 1097.84 1.2540e-07 1097.84 1.2560e-07 1097.84 1.2580e-07 1097.84 1.2600e-07 1097.84 1.2620e-07 1097.84 1.2640e-07 1097.83 1.2660e-07 1097.83 1.2680e-07 1097.83 1.2700e-07 1097.83 1.2720e-07 1097.83 1.2740e-07 1097.83 1.2760e-07 1097.83 1.2780e-07 1097.83 1.2800e-07 1097.83 1.2820e-07 1097.83 1.2840e-07 1097.83 1.2860e-07 1097.83 1.2880e-07 1097.83 1.2900e-07 1097.83 1.2920e-07 1097.82 1.2940e-07 1097.82 1.2960e-07 1097.82 1.2980e-07 1097.82 1.3000e-07 1097.82 1.3020e-07 1097.82 1.3040e-07 1097.82 1.3060e-07 1097.82 1.3080e-07 1097.82 1.3100e-07 1097.82 1.3120e-07 1097.82 1.3140e-07 1097.82 1.3160e-07 1097.82 1.3180e-07 1097.81 1.3200e-07 1097.81 1.3220e-07 1097.81 1.3240e-07 1097.81 1.3260e-07 1097.81 1.3280e-07 1097.81 1.3300e-07 1097.81 1.3320e-07 1097.81 1.3340e-07 1097.81 1.3360e-07 1097.81 1.3380e-07 1097.81 1.3400e-07 1097.81 1.3420e-07 1097.81 1.3440e-07 1097.81 1.3460e-07 1097.80 1.3480e-07 1097.80 1.3500e-07 1097.80 1.3520e-07 1097.80 1.3540e-07 1097.80 1.3560e-07 1097.80 1.3580e-07 1097.80 1.3600e-07 1097.80 1.3620e-07 1097.80 1.3640e-07 1097.80 1.3660e-07 1097.80 1.3680e-07 1097.80 1.3700e-07 1097.80 1.3720e-07 1097.80 1.3740e-07 1097.79 1.3760e-07 1097.79 1.3780e-07 1097.79 1.3800e-07 1097.79 1.3820e-07 1097.79 1.3840e-07 1097.79 1.3860e-07 1097.79 1.3880e-07 1097.79 1.3900e-07 1097.79 1.3920e-07 1097.79 1.3940e-07 1097.79 1.3960e-07 1097.79 1.3980e-07 1097.79 1.4000e-07 1097.78 1.4020e-07 1097.78 1.4040e-07 1097.78 1.4060e-07 1097.78 1.4080e-07 1097.78 1.4100e-07 1097.78 1.4120e-07 1097.78 1.4140e-07 1097.78 1.4160e-07 1097.78 1.4180e-07 1097.78 1.4200e-07 1097.78 1.4220e-07 1097.78 1.4240e-07 1097.78 1.4260e-07 1097.78 1.4280e-07 1097.77 1.4300e-07 1097.77 1.4320e-07 1097.77 1.4340e-07 1097.77 1.4360e-07 1097.77 1.4380e-07 1097.77 1.4400e-07 1097.77 1.4420e-07 1097.77 1.4440e-07 1097.77 1.4460e-07 1097.77 1.4480e-07 1097.77 1.4500e-07 1097.77 1.4520e-07 1097.77 1.4540e-07 1097.77 1.4560e-07 1097.76 1.4580e-07 1097.76 1.4600e-07 1097.76 1.4620e-07 1097.76 1.4640e-07 1097.76 1.4660e-07 1097.76 1.4680e-07 1097.76 1.4700e-07 1097.76 1.4720e-07 1097.76 1.4740e-07 1097.76 1.4760e-07 1097.76 1.4780e-07 1097.76 1.4800e-07 1097.76 1.4820e-07 1097.76 1.4840e-07 1097.75 1.4860e-07 1097.75 1.4880e-07 1097.75 1.4900e-07 1097.75 1.4920e-07 1097.75 1.4940e-07 1097.75 1.4960e-07 1097.75 1.4980e-07 1097.75 1.5000e-07 1097.75 1.5020e-07 1097.75 1.5040e-07 1097.75 1.5060e-07 1097.75 1.5080e-07 1097.75 1.5100e-07 1097.75 1.5120e-07 1097.74 1.5140e-07 1097.74 1.5160e-07 1097.74 1.5180e-07 1097.74 1.5200e-07 1097.74 1.5220e-07 1097.74 1.5240e-07 1097.74 1.5260e-07 1097.74 1.5280e-07 1097.74 1.5300e-07 1097.74 1.5320e-07 1097.74 1.5340e-07 1097.74 1.5360e-07 1097.74 1.5380e-07 1097.74 1.5400e-07 1097.73 1.5420e-07 1097.73 1.5440e-07 1097.73 1.5460e-07 1097.73 1.5480e-07 1097.73 1.5500e-07 1097.73 1.5520e-07 1097.73 1.5540e-07 1097.73 1.5560e-07 1097.73 1.5580e-07 1097.73 1.5600e-07 1097.73 1.5620e-07 1097.73 1.5640e-07 1097.73 1.5660e-07 1097.73 1.5680e-07 1097.72 1.5700e-07 1097.72 1.5720e-07 1097.72 1.5740e-07 1097.72 1.5760e-07 1097.72 1.5780e-07 1097.72 1.5800e-07 1097.72 1.5820e-07 1097.72 1.5840e-07 1097.72 1.5860e-07 1097.72 1.5880e-07 1097.72 1.5900e-07 1097.72 1.5920e-07 1097.72 1.5940e-07 1097.72 1.5960e-07 1097.71 1.5980e-07 1097.71 1.6000e-07 1097.71 1.6020e-07 1097.71 1.6040e-07 1097.71 1.6060e-07 1097.71 1.6080e-07 1097.71 1.6100e-07 1097.71 1.6120e-07 1097.71 1.6140e-07 1097.71 1.6160e-07 1097.71 1.6180e-07 1097.71 1.6200e-07 1097.71 1.6220e-07 1097.71 1.6240e-07 1097.70 1.6260e-07 1097.70 1.6280e-07 1097.70 1.6300e-07 1097.70 1.6320e-07 1097.70 1.6340e-07 1097.70 1.6360e-07 1097.70 1.6380e-07 1097.70 1.6400e-07 1097.70 1.6420e-07 1097.70 1.6440e-07 1097.70 1.6460e-07 1097.70 1.6480e-07 1097.70 1.6500e-07 1097.70 1.6520e-07 1097.69 1.6540e-07 1097.69 1.6560e-07 1097.69 1.6580e-07 1097.69 1.6600e-07 1097.69 1.6620e-07 1097.69 1.6640e-07 1097.69 1.6660e-07 1097.69 1.6680e-07 1097.69 1.6700e-07 1097.69 1.6720e-07 1097.69 1.6740e-07 1097.69 1.6760e-07 1097.69 1.6780e-07 1097.68 1.6800e-07 1097.68 1.6820e-07 1097.68 1.6840e-07 1097.68 1.6860e-07 1097.68 1.6880e-07 1097.68 1.6900e-07 1097.68 1.6920e-07 1097.68 1.6940e-07 1097.68 1.6960e-07 1097.68 1.6980e-07 1097.68 1.7000e-07 1097.68 1.7020e-07 1097.68 1.7040e-07 1097.68 1.7060e-07 1097.67 1.7080e-07 1097.67 1.7100e-07 1097.67 1.7120e-07 1097.67 1.7140e-07 1097.67 1.7160e-07 1097.67 1.7180e-07 1097.67 1.7200e-07 1097.67 1.7220e-07 1097.67 1.7240e-07 1097.67 1.7260e-07 1097.67 1.7280e-07 1097.67 1.7300e-07 1097.67 1.7320e-07 1097.67 1.7340e-07 1097.66 1.7360e-07 1097.66 1.7380e-07 1097.66 1.7400e-07 1097.66 1.7420e-07 1097.66 1.7440e-07 1097.66 1.7460e-07 1097.66 1.7480e-07 1097.66 1.7500e-07 1097.66 1.7520e-07 1097.66 1.7540e-07 1097.66 1.7560e-07 1097.66 1.7580e-07 1097.66 1.7600e-07 1097.66 1.7620e-07 1097.65 1.7640e-07 1097.65 1.7660e-07 1097.65 1.7680e-07 1097.65 1.7700e-07 1097.65 1.7720e-07 1097.65 1.7740e-07 1097.65 1.7760e-07 1097.65 1.7780e-07 1097.65 1.7800e-07 1097.65 1.7820e-07 1097.65 1.7840e-07 1097.65 1.7860e-07 1097.65 1.7880e-07 1097.65 1.7900e-07 1097.64 1.7920e-07 1097.64 1.7940e-07 1097.64 1.7960e-07 1097.64 1.7980e-07 1097.64 1.8000e-07 1097.64 1.8020e-07 1097.64 1.8040e-07 1097.64 1.8060e-07 1097.64 1.8080e-07 1097.64 1.8100e-07 1097.64 1.8120e-07 1097.64 1.8140e-07 1097.64 1.8160e-07 1097.64 1.8180e-07 1097.63 1.8200e-07 1097.63 1.8220e-07 1097.63 1.8240e-07 1097.63 1.8260e-07 1097.63 1.8280e-07 1097.63 1.8300e-07 1097.63 1.8320e-07 1097.63 1.8340e-07 1097.63 1.8360e-07 1097.63 1.8380e-07 1097.63 1.8400e-07 1097.63 1.8420e-07 1097.63 1.8440e-07 1097.63 1.8460e-07 1097.62 1.8480e-07 1097.62 1.8500e-07 1097.62 1.8520e-07 1097.62 1.8540e-07 1097.62 1.8560e-07 1097.62 1.8580e-07 1097.62 1.8600e-07 1097.62 1.8620e-07 1097.62 1.8640e-07 1097.62 1.8660e-07 1097.62 1.8680e-07 1097.62 1.8700e-07 1097.62 1.8720e-07 1097.62 1.8740e-07 1097.61 1.8760e-07 1097.61 1.8780e-07 1097.61 1.8800e-07 1097.61 1.8820e-07 1097.61 1.8840e-07 1097.61 1.8860e-07 1097.61 1.8880e-07 1097.61 1.8900e-07 1097.61 1.8920e-07 1097.61 1.8940e-07 1097.61 1.8960e-07 1097.61 1.8980e-07 1097.61 1.9000e-07 1097.61 1.9020e-07 1097.60 1.9040e-07 1097.60 1.9060e-07 1097.60 1.9080e-07 1097.60 1.9100e-07 1097.60 1.9120e-07 1097.60 1.9140e-07 1097.60 1.9160e-07 1097.60 1.9180e-07 1097.60 1.9200e-07 1097.60 1.9220e-07 1097.60 1.9240e-07 1097.60 1.9260e-07 1097.60 1.9280e-07 1097.60 1.9300e-07 1097.59 1.9320e-07 1097.59 1.9340e-07 1097.59 1.9360e-07 1097.59 1.9380e-07 1097.59 1.9400e-07 1097.59 1.9420e-07 1097.59 1.9440e-07 1097.59 1.9460e-07 1097.59 1.9480e-07 1097.59 1.9500e-07 1097.59 1.9520e-07 1097.59 1.9540e-07 1097.59 1.9560e-07 1097.58 1.9580e-07 1097.58 1.9600e-07 1097.58 1.9620e-07 1097.58 1.9640e-07 1097.58 1.9660e-07 1097.58 1.9680e-07 1097.58 1.9700e-07 1097.58 1.9720e-07 1097.58 1.9740e-07 1097.58 1.9760e-07 1097.58 1.9780e-07 1097.58 1.9800e-07 1097.58 1.9820e-07 1097.58 1.9840e-07 1097.57 1.9860e-07 1097.57 1.9880e-07 1097.57 1.9900e-07 1097.57 1.9920e-07 1097.57 1.9940e-07 1097.57 1.9960e-07 1097.57 1.9980e-07 1097.57 2.0000e-07 1097.57 2.0020e-07 1097.57 2.0040e-07 1097.57 2.0060e-07 1097.57 2.0080e-07 1097.57 2.0100e-07 1097.57 2.0120e-07 1097.56 2.0140e-07 1097.56 2.0160e-07 1097.56 2.0180e-07 1097.56 2.0200e-07 1097.56 2.0220e-07 1097.56 2.0240e-07 1097.56 2.0260e-07 1097.56 2.0280e-07 1097.56 2.0300e-07 1097.56 2.0320e-07 1097.56 2.0340e-07 1097.56 2.0360e-07 1097.56 2.0380e-07 1097.56 2.0400e-07 1097.55 2.0420e-07 1097.55 2.0440e-07 1097.55 2.0460e-07 1097.55 2.0480e-07 1097.55 2.0500e-07 1097.55 2.0520e-07 1097.55 2.0540e-07 1097.55 2.0560e-07 1097.55 2.0580e-07 1097.55 2.0600e-07 1097.55 2.0620e-07 1097.55 2.0640e-07 1097.55 2.0660e-07 1097.55 2.0680e-07 1097.54 2.0700e-07 1097.54 2.0720e-07 1097.54 2.0740e-07 1097.54 2.0760e-07 1097.54 2.0780e-07 1097.54 2.0800e-07 1097.54 2.0820e-07 1097.54 2.0840e-07 1097.54 2.0860e-07 1097.54 2.0880e-07 1097.54 2.0900e-07 1097.54 2.0920e-07 1097.54 2.0940e-07 1097.54 2.0960e-07 1097.53 2.0980e-07 1097.53 2.1000e-07 1097.53 2.1020e-07 1097.53 2.1040e-07 1097.53 2.1060e-07 1097.53 2.1080e-07 1097.53 2.1100e-07 1097.53 2.1120e-07 1097.53 2.1140e-07 1097.53 2.1160e-07 1097.53 2.1180e-07 1097.53 2.1200e-07 1097.53 2.1220e-07 1097.53 2.1240e-07 1097.52 2.1260e-07 1097.52 2.1280e-07 1097.52 2.1300e-07 1097.52 2.1320e-07 1097.52 2.1340e-07 1097.52 2.1360e-07 1097.52 2.1380e-07 1097.52 2.1400e-07 1097.52 2.1420e-07 1097.52 2.1440e-07 1097.52 2.1460e-07 1097.52 2.1480e-07 1097.52 2.1500e-07 1097.52 2.1520e-07 1097.51 2.1540e-07 1097.51 2.1560e-07 1097.51 2.1580e-07 1097.51 2.1600e-07 1097.51 2.1620e-07 1097.51 2.1640e-07 1097.51 2.1660e-07 1097.51 2.1680e-07 1097.51 2.1700e-07 1097.51 2.1720e-07 1097.51 2.1740e-07 1097.51 2.1760e-07 1097.51 2.1780e-07 1097.50 2.1800e-07 1097.50 2.1820e-07 1097.50 2.1840e-07 1097.50 2.1860e-07 1097.50 2.1880e-07 1097.50 2.1900e-07 1097.50 2.1920e-07 1097.50 2.1940e-07 1097.50 2.1960e-07 1097.50 2.1980e-07 1097.50 2.2000e-07 1097.50 2.2020e-07 1097.50 2.2040e-07 1097.50 2.2060e-07 1097.49 2.2080e-07 1097.49 2.2100e-07 1097.49 2.2120e-07 1097.49 2.2140e-07 1097.49 2.2160e-07 1097.49 2.2180e-07 1097.49 2.2200e-07 1097.49 2.2220e-07 1097.49 2.2240e-07 1097.49 2.2260e-07 1097.49 2.2280e-07 1097.49 2.2300e-07 1097.49 2.2320e-07 1097.49 2.2340e-07 1097.48 2.2360e-07 1097.48 2.2380e-07 1097.48 2.2400e-07 1097.48 2.2420e-07 1097.48 2.2440e-07 1097.48 2.2460e-07 1097.48 2.2480e-07 1097.48 2.2500e-07 1097.48 2.2520e-07 1097.48 2.2540e-07 1097.48 2.2560e-07 1097.48 2.2580e-07 1097.48 2.2600e-07 1097.48 2.2620e-07 1097.47 2.2640e-07 1097.47 2.2660e-07 1097.47 2.2680e-07 1097.47 2.2700e-07 1097.47 2.2720e-07 1097.47 2.2740e-07 1097.47 2.2760e-07 1097.47 2.2780e-07 1097.47 2.2800e-07 1097.47 2.2820e-07 1097.47 2.2840e-07 1097.47 2.2860e-07 1097.47 2.2880e-07 1097.47 2.2900e-07 1097.46 2.2920e-07 1097.46 2.2940e-07 1097.46 2.2960e-07 1097.46 2.2980e-07 1097.46 2.3000e-07 1097.46 2.3020e-07 1097.46 2.3040e-07 1097.46 2.3060e-07 1097.46 2.3080e-07 1097.46 2.3100e-07 1097.46 2.3120e-07 1097.46 2.3140e-07 1097.46 2.3160e-07 1097.46 2.3180e-07 1097.45 2.3200e-07 1097.45 2.3220e-07 1097.45 2.3240e-07 1097.45 2.3260e-07 1097.45 2.3280e-07 1097.45 2.3300e-07 1097.45 2.3320e-07 1097.45 2.3340e-07 1097.45 2.3360e-07 1097.45 2.3380e-07 1097.45 2.3400e-07 1097.45 2.3420e-07 1097.45 2.3440e-07 1097.45 2.3460e-07 1097.44 2.3480e-07 1097.44 2.3500e-07 1097.44 2.3520e-07 1097.44 2.3540e-07 1097.44 2.3560e-07 1097.44 2.3580e-07 1097.44 2.3600e-07 1097.44 2.3620e-07 1097.44 2.3640e-07 1097.44 2.3660e-07 1097.44 2.3680e-07 1097.44 2.3700e-07 1097.44 2.3720e-07 1097.44 2.3740e-07 1097.43 2.3760e-07 1097.43 2.3780e-07 1097.43 2.3800e-07 1097.43 2.3820e-07 1097.43 2.3840e-07 1097.43 2.3860e-07 1097.43 2.3880e-07 1097.43 2.3900e-07 1097.43 2.3920e-07 1097.43 2.3940e-07 1097.43 2.3960e-07 1097.43 2.3980e-07 1097.43 2.4000e-07 1097.43 2.4020e-07 1097.42 2.4040e-07 1097.42 2.4060e-07 1097.42 2.4080e-07 1097.42 2.4100e-07 1097.42 2.4120e-07 1097.42 2.4140e-07 1097.42 2.4160e-07 1097.42 2.4180e-07 1097.42 2.4200e-07 1097.42 2.4220e-07 1097.42 2.4240e-07 1097.42 2.4260e-07 1097.42 2.4280e-07 1097.42 2.4300e-07 1097.41 2.4320e-07 1097.41 2.4340e-07 1097.41 2.4360e-07 1097.41 2.4380e-07 1097.41 2.4400e-07 1097.41 2.4420e-07 1097.41 2.4440e-07 1097.41 2.4460e-07 1097.41 2.4480e-07 1097.41 2.4500e-07 1097.41 2.4520e-07 1097.41 2.4540e-07 1097.41 2.4560e-07 1097.41 2.4580e-07 1097.40 2.4600e-07 1097.40 2.4620e-07 1097.40 2.4640e-07 1097.40 2.4660e-07 1097.40 2.4680e-07 1097.40 2.4700e-07 1097.40 2.4720e-07 1097.40 2.4740e-07 1097.40 2.4760e-07 1097.40 2.4780e-07 1097.40 2.4800e-07 1097.40 2.4820e-07 1097.40 2.4840e-07 1097.39 2.4860e-07 1097.39 2.4880e-07 1097.39 2.4900e-07 1097.39 2.4920e-07 1097.39 2.4940e-07 1097.39 2.4960e-07 1097.39 2.4980e-07 1097.39 2.5000e-07 1097.39 2.5020e-07 1097.39 2.5040e-07 1097.39 2.5060e-07 1097.39 2.5080e-07 1097.39 2.5100e-07 1097.39 2.5120e-07 1097.39 2.5140e-07 1097.38 2.5160e-07 1097.38 2.5180e-07 1097.38 2.5200e-07 1097.38 2.5220e-07 1097.38 2.5240e-07 1097.38 2.5260e-07 1097.38 2.5280e-07 1097.38 2.5300e-07 1097.38 2.5320e-07 1097.38 2.5340e-07 1097.38 2.5360e-07 1097.38 2.5380e-07 1097.38 2.5400e-07 1097.38 2.5420e-07 1097.37 2.5440e-07 1097.37 2.5460e-07 1097.37 2.5480e-07 1097.37 2.5500e-07 1097.37 2.5520e-07 1097.37 2.5540e-07 1097.37 2.5560e-07 1097.37 2.5580e-07 1097.37 2.5600e-07 1097.37 2.5620e-07 1097.37 2.5640e-07 1097.37 2.5660e-07 1097.37 2.5680e-07 1097.37 2.5700e-07 1097.36 2.5720e-07 1097.36 2.5740e-07 1097.36 2.5760e-07 1097.36 2.5780e-07 1097.36 2.5800e-07 1097.36 2.5820e-07 1097.36 2.5840e-07 1097.36 2.5860e-07 1097.36 2.5880e-07 1097.36 2.5900e-07 1097.36 2.5920e-07 1097.36 2.5940e-07 1097.36 2.5960e-07 1097.36 2.5980e-07 1097.35 2.6000e-07 1097.35 2.6020e-07 1097.35 2.6040e-07 1097.35 2.6060e-07 1097.35 2.6080e-07 1097.35 2.6100e-07 1097.35 2.6120e-07 1097.35 2.6140e-07 1097.35 2.6160e-07 1097.35 2.6180e-07 1097.35 2.6200e-07 1097.35 2.6220e-07 1097.35 2.6240e-07 1097.35 2.6260e-07 1097.34 2.6280e-07 1097.34 2.6300e-07 1097.34 2.6320e-07 1097.34 2.6340e-07 1097.34 2.6360e-07 1097.34 2.6380e-07 1097.34 2.6400e-07 1097.34 2.6420e-07 1097.34 2.6440e-07 1097.34 2.6460e-07 1097.34 2.6480e-07 1097.34 2.6500e-07 1097.34 2.6520e-07 1097.34 2.6540e-07 1097.33 2.6560e-07 1097.33 2.6580e-07 1097.33 2.6600e-07 1097.33 2.6620e-07 1097.33 2.6640e-07 1097.33 2.6660e-07 1097.33 2.6680e-07 1097.33 2.6700e-07 1097.33 2.6720e-07 1097.33 2.6740e-07 1097.33 2.6760e-07 1097.33 2.6780e-07 1097.33 2.6800e-07 1097.33 2.6820e-07 1097.32 2.6840e-07 1097.32 2.6860e-07 1097.32 2.6880e-07 1097.32 2.6900e-07 1097.32 2.6920e-07 1097.32 2.6940e-07 1097.32 2.6960e-07 1097.32 2.6980e-07 1097.32 2.7000e-07 1097.32 2.7020e-07 1097.32 2.7040e-07 1097.32 2.7060e-07 1097.32 2.7080e-07 1097.32 2.7100e-07 1097.31 2.7120e-07 1097.31 2.7140e-07 1097.31 2.7160e-07 1097.31 2.7180e-07 1097.31 2.7200e-07 1097.31 2.7220e-07 1097.31 2.7240e-07 1097.31 2.7260e-07 1097.31 2.7280e-07 1097.31 2.7300e-07 1097.31 2.7320e-07 1097.31 2.7340e-07 1097.31 2.7360e-07 1097.31 2.7380e-07 1097.30 2.7400e-07 1097.30 2.7420e-07 1097.30 2.7440e-07 1097.30 2.7460e-07 1097.30 2.7480e-07 1097.30 2.7500e-07 1097.30 2.7520e-07 1097.30 2.7540e-07 1097.30 2.7560e-07 1097.30 2.7580e-07 1097.30 2.7600e-07 1097.30 2.7620e-07 1097.30 2.7640e-07 1097.30 2.7660e-07 1097.30 2.7680e-07 1097.29 2.7700e-07 1097.29 2.7720e-07 1097.29 2.7740e-07 1097.29 2.7760e-07 1097.29 2.7780e-07 1097.29 2.7800e-07 1097.29 2.7820e-07 1097.29 2.7840e-07 1097.29 2.7860e-07 1097.29 2.7880e-07 1097.29 2.7900e-07 1097.29 2.7920e-07 1097.29 2.7940e-07 1097.29 2.7960e-07 1097.28 2.7980e-07 1097.28 2.8000e-07 1097.28 2.8020e-07 1097.28 2.8040e-07 1097.28 2.8060e-07 1097.28 2.8080e-07 1097.28 2.8100e-07 1097.28 2.8120e-07 1097.28 2.8140e-07 1097.28 2.8160e-07 1097.28 2.8180e-07 1097.28 2.8200e-07 1097.28 2.8220e-07 1097.28 2.8240e-07 1097.27 2.8260e-07 1097.27 2.8280e-07 1097.27 2.8300e-07 1097.27 2.8320e-07 1097.27 2.8340e-07 1097.27 2.8360e-07 1097.27 2.8380e-07 1097.27 2.8400e-07 1097.27 2.8420e-07 1097.27 2.8440e-07 1097.27 2.8460e-07 1097.27 2.8480e-07 1097.27 2.8500e-07 1097.27 2.8520e-07 1097.26 2.8540e-07 1097.26 2.8560e-07 1097.26 2.8580e-07 1097.26 2.8600e-07 1097.26 2.8620e-07 1097.26 2.8640e-07 1097.26 2.8660e-07 1097.26 2.8680e-07 1097.26 2.8700e-07 1097.26 2.8720e-07 1097.26 2.8740e-07 1097.26 2.8760e-07 1097.26 2.8780e-07 1097.26 2.8800e-07 1097.26 2.8820e-07 1097.25 2.8840e-07 1097.25 2.8860e-07 1097.25 2.8880e-07 1097.25 2.8900e-07 1097.25 2.8920e-07 1097.25 2.8940e-07 1097.25 2.8960e-07 1097.25 2.8980e-07 1097.25 2.9000e-07 1097.25 2.9020e-07 1097.25 2.9040e-07 1097.25 2.9060e-07 1097.25 2.9080e-07 1097.25 2.9100e-07 1097.24 2.9120e-07 1097.24 2.9140e-07 1097.24 2.9160e-07 1097.24 2.9180e-07 1097.24 2.9200e-07 1097.24 2.9220e-07 1097.24 2.9240e-07 1097.24 2.9260e-07 1097.24 2.9280e-07 1097.24 2.9300e-07 1097.24 2.9320e-07 1097.24 2.9340e-07 1097.24 2.9360e-07 1097.24 2.9380e-07 1097.24 2.9400e-07 1097.23 2.9420e-07 1097.23 2.9440e-07 1097.23 2.9460e-07 1097.23 2.9480e-07 1097.23 2.9500e-07 1097.23 2.9520e-07 1097.23 2.9540e-07 1097.23 2.9560e-07 1097.23 2.9580e-07 1097.23 2.9600e-07 1097.23 2.9620e-07 1097.23 2.9640e-07 1097.23 2.9660e-07 1097.23 2.9680e-07 1097.22 2.9700e-07 1097.22 2.9720e-07 1097.22 2.9740e-07 1097.22 2.9760e-07 1097.22 2.9780e-07 1097.22 2.9800e-07 1097.22 2.9820e-07 1097.22 2.9840e-07 1097.22 2.9860e-07 1097.22 2.9880e-07 1097.22 2.9900e-07 1097.22 2.9920e-07 1097.22 2.9940e-07 1097.22 2.9960e-07 1097.22 2.9980e-07 1097.21 3.0000e-07 1097.21 3.0020e-07 1097.21 3.0040e-07 1097.21 3.0060e-07 1097.21 3.0080e-07 1097.21 3.0100e-07 1097.21 3.0120e-07 1097.21 3.0140e-07 1097.21 3.0160e-07 1097.21 3.0180e-07 1097.21 3.0200e-07 1097.21 3.0220e-07 1097.21 3.0240e-07 1097.21 3.0260e-07 1097.20 3.0280e-07 1097.20 3.0300e-07 1097.20 3.0320e-07 1097.20 3.0340e-07 1097.20 3.0360e-07 1097.20 3.0380e-07 1097.20 3.0400e-07 1097.20 3.0420e-07 1097.20 3.0440e-07 1097.20 3.0460e-07 1097.20 3.0480e-07 1097.20 3.0500e-07 1097.20 3.0520e-07 1097.20 3.0540e-07 1097.20 3.0560e-07 1097.19 3.0580e-07 1097.19 3.0600e-07 1097.19 3.0620e-07 1097.19 3.0640e-07 1097.19 3.0660e-07 1097.19 3.0680e-07 1097.19 3.0700e-07 1097.19 3.0720e-07 1097.19 3.0740e-07 1097.19 3.0760e-07 1097.19 3.0780e-07 1097.19 3.0800e-07 1097.19 3.0820e-07 1097.19 3.0840e-07 1097.19 3.0860e-07 1097.18 3.0880e-07 1097.18 3.0900e-07 1097.18 3.0920e-07 1097.18 3.0940e-07 1097.18 3.0960e-07 1097.18 3.0980e-07 1097.18 3.1000e-07 1097.18 3.1020e-07 1097.18 3.1040e-07 1097.18 3.1060e-07 1097.18 3.1080e-07 1097.18 3.1100e-07 1097.18 3.1120e-07 1097.18 3.1140e-07 1097.17 3.1160e-07 1097.17 3.1180e-07 1097.17 3.1200e-07 1097.17 3.1220e-07 1097.17 3.1240e-07 1097.17 3.1260e-07 1097.17 3.1280e-07 1097.17 3.1300e-07 1097.17 3.1320e-07 1097.17 3.1340e-07 1097.17 3.1360e-07 1097.17 3.1380e-07 1097.17 3.1400e-07 1097.17 3.1420e-07 1097.17 3.1440e-07 1097.16 3.1460e-07 1097.16 3.1480e-07 1097.16 3.1500e-07 1097.16 3.1520e-07 1097.16 3.1540e-07 1097.16 3.1560e-07 1097.16 3.1580e-07 1097.16 3.1600e-07 1097.16 3.1620e-07 1097.16 3.1640e-07 1097.16 3.1660e-07 1097.16 3.1680e-07 1097.16 3.1700e-07 1097.16 3.1720e-07 1097.16 3.1740e-07 1097.15 3.1760e-07 1097.15 3.1780e-07 1097.15 3.1800e-07 1097.15 3.1820e-07 1097.15 3.1840e-07 1097.15 3.1860e-07 1097.15 3.1880e-07 1097.15 3.1900e-07 1097.15 3.1920e-07 1097.15 3.1940e-07 1097.15 3.1960e-07 1097.15 3.1980e-07 1097.15 3.2000e-07 1097.15 3.2020e-07 1097.15 3.2040e-07 1097.14 3.2060e-07 1097.14 3.2080e-07 1097.14 3.2100e-07 1097.14 3.2120e-07 1097.14 3.2140e-07 1097.14 3.2160e-07 1097.14 3.2180e-07 1097.14 3.2200e-07 1097.14 3.2220e-07 1097.14 3.2240e-07 1097.14 3.2260e-07 1097.14 3.2280e-07 1097.14 3.2300e-07 1097.14 3.2320e-07 1097.14 3.2340e-07 1097.13 3.2360e-07 1097.13 3.2380e-07 1097.13 3.2400e-07 1097.13 3.2420e-07 1097.13 3.2440e-07 1097.13 3.2460e-07 1097.13 3.2480e-07 1097.13 3.2500e-07 1097.13 3.2520e-07 1097.13 3.2540e-07 1097.13 3.2560e-07 1097.13 3.2580e-07 1097.13 3.2600e-07 1097.13 3.2620e-07 1097.13 3.2640e-07 1097.12 3.2660e-07 1097.12 3.2680e-07 1097.12 3.2700e-07 1097.12 3.2720e-07 1097.12 3.2740e-07 1097.12 3.2760e-07 1097.12 3.2780e-07 1097.12 3.2800e-07 1097.12 3.2820e-07 1097.12 3.2840e-07 1097.12 3.2860e-07 1097.12 3.2880e-07 1097.12 3.2900e-07 1097.12 3.2920e-07 1097.12 3.2940e-07 1097.11 3.2960e-07 1097.11 3.2980e-07 1097.11 3.3000e-07 1097.11 3.3020e-07 1097.11 3.3040e-07 1097.11 3.3060e-07 1097.11 3.3080e-07 1097.11 3.3100e-07 1097.11 3.3120e-07 1097.11 3.3140e-07 1097.11 3.3160e-07 1097.11 3.3180e-07 1097.11 3.3200e-07 1097.11 3.3220e-07 1097.11 3.3240e-07 1097.10 3.3260e-07 1097.10 3.3280e-07 1097.10 3.3300e-07 1097.10 3.3320e-07 1097.10 3.3340e-07 1097.10 3.3360e-07 1097.10 3.3380e-07 1097.10 3.3400e-07 1097.10 3.3420e-07 1097.10 3.3440e-07 1097.10 3.3460e-07 1097.10 3.3480e-07 1097.10 3.3500e-07 1097.10 3.3520e-07 1097.10 3.3540e-07 1097.09 3.3560e-07 1097.09 3.3580e-07 1097.09 3.3600e-07 1097.09 3.3620e-07 1097.09 3.3640e-07 1097.09 3.3660e-07 1097.09 3.3680e-07 1097.09 3.3700e-07 1097.09 3.3720e-07 1097.09 3.3740e-07 1097.09 3.3760e-07 1097.09 3.3780e-07 1097.09 3.3800e-07 1097.09 3.3820e-07 1097.09 3.3840e-07 1097.08 3.3860e-07 1097.08 3.3880e-07 1097.08 3.3900e-07 1097.08 3.3920e-07 1097.08 3.3940e-07 1097.08 3.3960e-07 1097.08 3.3980e-07 1097.08 3.4000e-07 1097.08 3.4020e-07 1097.08 3.4040e-07 1097.08 3.4060e-07 1097.08 3.4080e-07 1097.08 3.4100e-07 1097.08 3.4120e-07 1097.08 3.4140e-07 1097.08 3.4160e-07 1097.07 3.4180e-07 1097.07 3.4200e-07 1097.07 3.4220e-07 1097.07 3.4240e-07 1097.07 3.4260e-07 1097.07 3.4280e-07 1097.07 3.4300e-07 1097.07 3.4320e-07 1097.07 3.4340e-07 1097.07 3.4360e-07 1097.07 3.4380e-07 1097.07 3.4400e-07 1097.07 3.4420e-07 1097.07 3.4440e-07 1097.07 3.4460e-07 1097.06 3.4480e-07 1097.06 3.4500e-07 1097.06 3.4520e-07 1097.06 3.4540e-07 1097.06 3.4560e-07 1097.06 3.4580e-07 1097.06 3.4600e-07 1097.06 3.4620e-07 1097.06 3.4640e-07 1097.06 3.4660e-07 1097.06 3.4680e-07 1097.06 3.4700e-07 1097.06 3.4720e-07 1097.06 3.4740e-07 1097.06 3.4760e-07 1097.05 3.4780e-07 1097.05 3.4800e-07 1097.05 3.4820e-07 1097.05 3.4840e-07 1097.05 3.4860e-07 1097.05 3.4880e-07 1097.05 3.4900e-07 1097.05 3.4920e-07 1097.05 3.4940e-07 1097.05 3.4960e-07 1097.05 3.4980e-07 1097.05 3.5000e-07 1097.05 3.5020e-07 1097.05 3.5040e-07 1097.05 3.5060e-07 1097.05 3.5080e-07 1097.04 3.5100e-07 1097.04 3.5120e-07 1097.04 3.5140e-07 1097.04 3.5160e-07 1097.04 3.5180e-07 1097.04 3.5200e-07 1097.04 3.5220e-07 1097.04 3.5240e-07 1097.04 3.5260e-07 1097.04 3.5280e-07 1097.04 3.5300e-07 1097.04 3.5320e-07 1097.04 3.5340e-07 1097.04 3.5360e-07 1097.04 3.5380e-07 1097.04 3.5400e-07 1097.03 3.5420e-07 1097.03 3.5440e-07 1097.03 3.5460e-07 1097.03 3.5480e-07 1097.03 3.5500e-07 1097.03 3.5520e-07 1097.03 3.5540e-07 1097.03 3.5560e-07 1097.03 3.5580e-07 1097.03 3.5600e-07 1097.03 3.5620e-07 1097.03 3.5640e-07 1097.03 3.5660e-07 1097.03 3.5680e-07 1097.03 3.5700e-07 1097.02 3.5720e-07 1097.02 3.5740e-07 1097.02 3.5760e-07 1097.02 3.5780e-07 1097.02 3.5800e-07 1097.02 3.5820e-07 1097.02 3.5840e-07 1097.02 3.5860e-07 1097.02 3.5880e-07 1097.02 3.5900e-07 1097.02 3.5920e-07 1097.02 3.5940e-07 1097.02 3.5960e-07 1097.02 3.5980e-07 1097.02 3.6000e-07 1097.02 3.6020e-07 1097.01 3.6040e-07 1097.01 3.6060e-07 1097.01 3.6080e-07 1097.01 3.6100e-07 1097.01 3.6120e-07 1097.01 3.6140e-07 1097.01 3.6160e-07 1097.01 3.6180e-07 1097.01 3.6200e-07 1097.01 3.6220e-07 1097.01 3.6240e-07 1097.01 3.6260e-07 1097.01 3.6280e-07 1097.01 3.6300e-07 1097.01 3.6320e-07 1097.01 3.6340e-07 1097.00 3.6360e-07 1097.00 3.6380e-07 1097.00 3.6400e-07 1097.00 3.6420e-07 1097.00 3.6440e-07 1097.00 3.6460e-07 1097.00 3.6480e-07 1097.00 3.6500e-07 1097.00 3.6520e-07 1097.00 3.6540e-07 1097.00 3.6560e-07 1097.00 3.6580e-07 1097.00 3.6600e-07 1097.00 3.6620e-07 1097.00 3.6640e-07 1097.00 3.6660e-07 1096.99 3.6680e-07 1096.99 3.6700e-07 1096.99 3.6720e-07 1096.99 3.6740e-07 1096.99 3.6760e-07 1096.99 3.6780e-07 1096.99 3.6800e-07 1096.99 3.6820e-07 1096.99 3.6840e-07 1096.99 3.6860e-07 1096.99 3.6880e-07 1096.99 3.6900e-07 1096.99 3.6920e-07 1096.99 3.6940e-07 1096.99 3.6960e-07 1096.99 3.6980e-07 1096.98 3.7000e-07 1096.98 3.7020e-07 1096.98 3.7040e-07 1096.98 3.7060e-07 1096.98 3.7080e-07 1096.98 3.7100e-07 1096.98 3.7120e-07 1096.98 3.7140e-07 1096.98 3.7160e-07 1096.98 3.7180e-07 1096.98 3.7200e-07 1096.98 3.7220e-07 1096.98 3.7240e-07 1096.98 3.7260e-07 1096.98 3.7280e-07 1096.98 3.7300e-07 1096.97 3.7320e-07 1096.97 3.7340e-07 1096.97 3.7360e-07 1096.97 3.7380e-07 1096.97 3.7400e-07 1096.97 3.7420e-07 1096.97 3.7440e-07 1096.97 3.7460e-07 1096.97 3.7480e-07 1096.97 3.7500e-07 1096.97 3.7520e-07 1096.97 3.7540e-07 1096.97 3.7560e-07 1096.97 3.7580e-07 1096.97 3.7600e-07 1096.97 3.7620e-07 1096.96 3.7640e-07 1096.96 3.7660e-07 1096.96 3.7680e-07 1096.96 3.7700e-07 1096.96 3.7720e-07 1096.96 3.7740e-07 1096.96 3.7760e-07 1096.96 3.7780e-07 1096.96 3.7800e-07 1096.96 3.7820e-07 1096.96 3.7840e-07 1096.96 3.7860e-07 1096.96 3.7880e-07 1096.96 3.7900e-07 1096.96 3.7920e-07 1096.96 3.7940e-07 1096.96 3.7960e-07 1096.95 3.7980e-07 1096.95 3.8000e-07 1096.95 3.8020e-07 1096.95 3.8040e-07 1096.95 3.8060e-07 1096.95 3.8080e-07 1096.95 3.8100e-07 1096.95 3.8120e-07 1096.95 3.8140e-07 1096.95 3.8160e-07 1096.95 3.8180e-07 1096.95 3.8200e-07 1096.95 3.8220e-07 1096.95 3.8240e-07 1096.95 3.8260e-07 1096.95 3.8280e-07 1096.94 3.8300e-07 1096.94 3.8320e-07 1096.94 3.8340e-07 1096.94 3.8360e-07 1096.94 3.8380e-07 1096.94 3.8400e-07 1096.94 3.8420e-07 1096.94 3.8440e-07 1096.94 3.8460e-07 1096.94 3.8480e-07 1096.94 3.8500e-07 1096.94 3.8520e-07 1096.94 3.8540e-07 1096.94 3.8560e-07 1096.94 3.8580e-07 1096.94 3.8600e-07 1096.93 3.8620e-07 1096.93 3.8640e-07 1096.93 3.8660e-07 1096.93 3.8680e-07 1096.93 3.8700e-07 1096.93 3.8720e-07 1096.93 3.8740e-07 1096.93 3.8760e-07 1096.93 3.8780e-07 1096.93 3.8800e-07 1096.93 3.8820e-07 1096.93 3.8840e-07 1096.93 3.8860e-07 1096.93 3.8880e-07 1096.93 3.8900e-07 1096.93 3.8920e-07 1096.93 3.8940e-07 1096.92 3.8960e-07 1096.92 3.8980e-07 1096.92 3.9000e-07 1096.92 3.9020e-07 1096.92 3.9040e-07 1096.92 3.9060e-07 1096.92 3.9080e-07 1096.92 3.9100e-07 1096.92 3.9120e-07 1096.92 3.9140e-07 1096.92 3.9160e-07 1096.92 3.9180e-07 1096.92 3.9200e-07 1096.92 3.9220e-07 1096.92 3.9240e-07 1096.92 3.9260e-07 1096.92 3.9280e-07 1096.91 3.9300e-07 1096.91 3.9320e-07 1096.91 3.9340e-07 1096.91 3.9360e-07 1096.91 3.9380e-07 1096.91 3.9400e-07 1096.91 3.9420e-07 1096.91 3.9440e-07 1096.91 3.9460e-07 1096.91 3.9480e-07 1096.91 3.9500e-07 1096.91 3.9520e-07 1096.91 3.9540e-07 1096.91 3.9560e-07 1096.91 3.9580e-07 1096.91 3.9600e-07 1096.91 3.9620e-07 1096.90 3.9640e-07 1096.90 3.9660e-07 1096.90 3.9680e-07 1096.90 3.9700e-07 1096.90 3.9720e-07 1096.90 3.9740e-07 1096.90 3.9760e-07 1096.90 3.9780e-07 1096.90 3.9800e-07 1096.90 3.9820e-07 1096.90 3.9840e-07 1096.90 3.9860e-07 1096.90 3.9880e-07 1096.90 3.9900e-07 1096.90 3.9920e-07 1096.90 3.9940e-07 1096.90 3.9960e-07 1096.89 3.9980e-07 1096.89 4.0000e-07 1096.89 4.0020e-07 1096.89 4.0040e-07 1096.89 4.0060e-07 1096.89 4.0080e-07 1096.89 4.0100e-07 1096.89 4.0120e-07 1096.89 4.0140e-07 1096.89 4.0160e-07 1096.89 4.0180e-07 1096.89 4.0200e-07 1096.89 4.0220e-07 1096.89 4.0240e-07 1096.89 4.0260e-07 1096.89 4.0280e-07 1096.89 4.0300e-07 1096.88 4.0320e-07 1096.88 4.0340e-07 1096.88 4.0360e-07 1096.88 4.0380e-07 1096.88 4.0400e-07 1096.88 4.0420e-07 1096.88 4.0440e-07 1096.88 4.0460e-07 1096.88 4.0480e-07 1096.88)
Vsense sl 0 0
Rksl kl sl 0.25
Vel vel kl -3.5
Ml0 dd gxl0 sl dut
Rgl0 vel gl0 4.5198433291323665
Rc0 gl0 cl0 0.08
Lc0 cl0 vl0 1e-09
Dc0 vl0 gl0 dbody
Cvl0 vl0 sl 1u
Rvl0 vel vl0 4.7
Rgs0 gl0 sl 10k
Ml1 dd gl1 sl dut
Rgl1 vel gl1 4.5198433291323665
Rc1 gl1 cl1 0.08
Lc1 cl1 vl1 1e-09
Dc1 vl1 gl1 dbody
Cvl1 vl1 sl 1u
Rvl1 vel vl1 4.7
Rgs1 gl1 sl 10k
Vig0 gl0 gxl0 0
.save v(dd) v(gl0) v(gxl0) i(Vig0) v(vl0) i(Vd)
.tran 0.05n 4.0490e-07 0 0.05n
.options method=gear maxord=2 reltol=2e-3 abstol=1e-9
.control
run
linearize v(dd) v(gl0) v(gxl0) i(Vig0) v(vl0) i(Vd)
wrdata pv_dpt_gdrv_vic_SG2M040170HJ_c1100_62.dat v(dd) v(gl0) v(gxl0) i(Vig0) v(vl0) i(Vd)
quit
.endc
.end
