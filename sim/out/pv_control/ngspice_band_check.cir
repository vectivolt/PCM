* PV cell band-mode check (generated by sim/pv_control.py): ideal switches, body diodes, dead time
.model sw SW(Ron=1m Roff=10Meg Vt=0.5 Vh=0)
.model bd D(Is=1e-12 N=0.05)
VA sa 0 800.02794615125
RSA sa sa2 0.001
LSA sa2 pa 1e-06 ic=27.946151249999996
CA pa 0 9.439999999999999e-05 ic=800.0
VB sb 0 789.9717001
RSB sb sb2 0.001
LSB sb2 pb 1e-06 ic=-28.2999
CB pb 0 9.439999999999999e-05 ic=790.0
S1 pa na g1 0 sw
D1 na pa bd
S2 na 0 g2 0 sw
D2 0 na bd
S3 pb nb g3 0 sw
D3 nb pb bd
S4 nb 0 g4 0 sw
D4 0 nb bd
L1 na x 0.00023641256574143482 ic=30.0
RL x nb 0.07122871056167965
Vg1a g1a 0 PULSE(0 1 0 1n 1n 1.455529e-05 3.125000e-05)
Vg1b g1b 0 PULSE(0 1 1.728071e-05 1n 1n 1.396929e-05 3.125000e-05)
Bg1 g1 0 V=max(v(g1a),v(g1b))
Vg2 g2 0 PULSE(0 1 1.514129e-05 1n 1n 1.553426e-06 3.125000e-05)
Vg3a g3a 0 PULSE(0 1 0 1n 1n 1.473953e-05 3.125000e-05)
Vg3b g3b 0 PULSE(0 1 1.709647e-05 1n 1n 1.415353e-05 3.125000e-05)
Bg3 g3 0 V=max(v(g3a),v(g3b))
Vg4 g4 0 PULSE(0 1 1.532553e-05 1n 1n 1.184937e-06 3.125000e-05)
.tran 2n 1.562500e-04 0 2n uic
.control
run
linearize i(L1)
wrdata /var/folders/zq/839xjjbx6z3c2w55r6gngzv00000gn/T/tmp6sebzq2z/band.dat i(L1)
quit
.endc
.end
