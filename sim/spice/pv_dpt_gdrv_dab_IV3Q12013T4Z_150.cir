* PVCELL commutation (double-pulse) test - InventChip IV3Q12013T4Z (proxy on the SG2M014120LJ library entry) gdrv_dab_IV3Q12013T4Z_150 x3, 950 V, 150.0 A, L_loop 15.0 nH, R_G 2.0 ohm per device. Generated by sim/pv_tradeoff.py
.model dut VDMOS(Vto=2.8 Kp=21.36 lambda=0.01 Rd=0.009419 Rs=0.5m Rg=2.3 Cgs=4.766e-09 Cgdmax=9.548e-10 Cgdmin=8.1e-12 a=0.02264 Cjo=3.32e-09 Vj=3 M=0.5 Is=7.58e-16 N=3 Rb=0.01121 Tt=0)
Vdc dcp 0 950.0
Rloop dcp dl 5m
Lloop dl dtop 1.5e-08
Rdamp dl dtop 10.0
Iload dtop mid 150.0
.model dsteer D(Is=1e-12 N=0.3)
Rclh0 gh0 ghd 0.6
Rclh1 gh1 ghd 0.6
Rclh2 gh2 ghd 0.6
Mh0 dtop gx0 mid dut
Rgh0 ghd gh0 2.0
Ml0 mid gl0 sl dut
Rgl0 gld gl0 2.0
Mh1 dtop gh1 mid dut
Rgh1 ghd gh1 2.0
Ml1 mid gl1 sl dut
Rgl1 gld gl1 2.0
Mh2 dtop gh2 mid dut
Rgh2 ghd gh2 2.0
Ml2 mid gl2 sl dut
Rgl2 gld gl2 2.0
Vig0 gh0 gx0 0
Vgh ghd kh -3.5
Rksh kh mid 0.16666666666666666
Vsense sl 0 0
Rksl kl sl 0.16666666666666666
Vgl gld kl PULSE(-3.5 18.0 1e-07 5e-09 5e-09 1e-06 1)
.save v(mid) v(dtop) v(gh0) i(Vsense) i(Lloop) v(gx0) i(Vig0)
.tran 0.05n 1.7e-06 0 0.05n
.options method=gear maxord=2 reltol=5e-3 abstol=1e-8
.control
run
linearize v(mid) v(dtop) v(gh0) i(Vsense) i(Lloop) v(gx0) i(Vig0)
wrdata pv_dpt_gdrv_dab_IV3Q12013T4Z_150.dat v(mid) v(dtop) v(gh0) i(Vsense) i(Lloop) v(gx0) i(Vig0)
quit
.endc
.end
