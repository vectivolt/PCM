* PVCELL port-A terminal short, 3 cells, bank 1100 V, clamp 1 x DD600N16K on the port board, per-cell equivalent of the shared loop. Generated by sim/pv_design.py
.model dbody D(Is=4.014e-05 N=10.28 Rs=0.01567 Cjo=1.049e-09 Vj=3 M=0.5)
.model dcl D(Is=4.629e-11 N=1.16 Rs=0.000645 Cjo=1e-10 Vj=0.7 M=0.5)
C1 c1 0 9e-05 ic=1100.0
Lesl c1 c2 9.5e-09
Resr c2 bp 0.00155
Lst bp pt 1e-08
Lm pt m1 1.5e-06
Rm m1 0 0.005207812500000001
Vsl 0 lx 0
Dlo lx l2 dbody m=2
Dhi l2 l1 dbody m=2
Lleg l1 bp 1.5e-08
Dcl 0 k1 dcl
Lcl k1 pt 1.5000000000000002e-08
.save v(c1) v(bp) i(Lm) i(Lesl) i(Vsl) v(l1) i(Lcl) v(k1)
.tran 8.64e-09 0.003456 0 2e-08 uic
.options method=gear maxord=2 reltol=2e-3 abstol=1e-6
.control
run
linearize v(c1) v(bp) i(Lm) i(Lesl) i(Vsl) v(l1) i(Lcl) v(k1)
wrdata pv_dump_3c_DD600_port.dat v(c1) v(bp) i(Lm) i(Lesl) i(Vsl) v(l1) i(Lcl) v(k1)
quit
.endc
.end
