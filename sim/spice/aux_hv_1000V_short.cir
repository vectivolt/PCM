* AUX-HV flyback, Vin = 1000 V, mode short - written by sim/aux_hv_design.py (do not edit)
* Behavioural UCC28C59: RT/CT oscillator (discharge latch, 8.4 mA), T flip-flop (every 2nd cycle, D < 48 %%),
* PWM D-latch reset by the CS comparator (1.15 V offset / gain 3 / 1.0 V clamp, tD 70 ns); C3M0900170J as
* switch + Co(tr); transformer from the calculation; TVS clamp; ATL431 + CNY65B loop; foldback detector;
* compensated tap string + TLV3202 OV lockout. Linear core: saturation is NOT modelled.
.param vin=1000
Vin hvin 0 {vin}
Rinr hvin bulk 44
Cbulk bulk 0 6.6e-06
Chf bulk 0 2.64e-08
Llk bulk pm 3.04212e-05
Vip pm pm2 0
Lp pm2 drain 0.00114825
Ls 0 sec 3.18959e-05
La 0 aux 3.62905e-05
K1 Lp Ls La 0.9995
Cw drain 0 3.29122e-11
Coss drain src 1.53e-11
S1 drain src gate 0 swmod
.model swmod sw(vt=7.5 vh=0.5 ron=1.28333 roff=1e9)
Rcs src 0 0.75
Dcl drain clmp dclamp
.model dclamp d(is=1e-12 n=1.5 rs=0.2 cjo=10p bv=2000)
Dtvs bulk clmp dtvs
.model dtvs d(is=1e-12 n=1.5 bv=245.7 ibv=1m rs=6.09023 cjo=100p)
Dout sec out dout
.model dout d(is=6.10913e-06 n=2.12302 rs=0.0271257 cjo=110p vj=1 m=0.35 tt=0)
Rsn sec snm 150
Csn snm out 6.8e-11
Resr out pol 0.00833333
Cpol pol 0 0.0003
Cml out 0 1e-05
Rload out 0 17.283
Daux aux vddr daux
.model daux d(is=1e-9 n=1.8 rs=0.3 cjo=20p)
Raux vddr vdd 22
Cvdd vdd 0 5.6e-05
Rvdd vdd 0 2018.97
* --- oscillator: RT from VREF, CT (+ C_TX through Q_FB), discharge latch hi 2.5 V / lo 0.7 V, 8.4 mA sink
Vref5 vref 0 5
Rt vref rtct 13700
Ct rtct 0 1e-09
Sfb rtct ctx fbk 0 swfb
.model swfb sw(vt=1.6 vh=0.1 ron=3 roff=1e10)
Cqfb rtct ctx 7e-12
Ctx ctx 0 1e-08
Bhi ohi 0 v = v(rtct) > 2.5 ? 1 : 0
Blo olo 0 v = v(rtct) < 0.72 ? 1 : 0
Bdis rtct 0 i = v(dis) * 0.0084 * min(max((v(rtct) - 0.7) / 0.05, 0), 1)
Ven en 0 1
abr1 [ohi olo en] [dhi dlo den] adcb
.model adcb adc_bridge(in_low=0.4 in_high=0.6)
alat2 dhi dlo den NULL NULL ddis ddisn srl
.model srl d_srlatch(sr_delay=1n enable_delay=1n set_delay=1n reset_delay=1n)
abd2 [ddis] [dis] dacb1
.model dacb1 dac_bridge(out_low=0 out_high=1 t_rise=1n t_fall=1n)
atff den ddis NULL NULL dtq dtqn tff
.model tff d_tff(clk_delay=1n)
adly ddisn dclk dly
.model dly d_buffer(rise_delay=10n fall_delay=10n)
* --- PWM latch: set at the end of an enabled discharge, reset by CS comparator (tD) or the next discharge
Rcsf src cs 1000
Ccsf cs 0 1.5e-10
Bcmp rstc 0 v = (v(cs) > min(max((v(comp)-1.15)/3, 0), 1)) ? 1 : 0
abr2 [rstc] [drc0] adcb
atd drc0 drc tdl
.model tdl d_buffer(rise_delay=7e-08 fall_delay=1n)
aor [drc ddis] drst or2
.model or2 d_or(rise_delay=1n fall_delay=1n)
adff dtq dclk NULL drst dq dqn dff
.model dff d_dff(clk_delay=1n reset_delay=1n)
abd [dq] [q] dacb
.model dacb dac_bridge(out_low=0 out_high=15 t_rise=20n t_fall=20n)
Rgx q gate 10
Cgx gate 0 200p
* --- COMP node: EA source current (FB below 2.5 V), pull-up to VREF, pole capacitor, opto collector
Iea vref comp 0.001
Dea comp vref dclp
.model dclp d(is=1e-12 n=1)
Rpu vref comp 2200
Cp comp 0 2.2e-09
Bopt comp 0 i = v(ctrf) * tanh(v(comp)/0.1)
Bctr 0 ctrf i = 0.9 * i(vled)
Rctr ctrf 0 1
Cctr ctrf 0 1.06103e-05
* --- secondary: ATL431 (ideal shunt, 1 S), fast lane R_LED, LED + R_bias, divider, integrator, R-C feed-forward
Rled out la 560
Rbias la k 4700
Dled la lk dled
.model dled d(is=1e-14 n=1.6)
Vled lk k 0
Rup out fbs 137000
Rlo fbs 0 16900
Cz k fbs 4.7e-08
Rff out ffm 33000
Cff ffm fbs 3.9e-08
Batl k 0 i = max(0, 1.0*(v(fbs)-2.5)) * (v(k) > 1 ? 1 : v(k))
* --- foldback: aux -> US1G -> 2.2k -> AF1 (1n, 10k) -> 6V8 Zener -> Q_INV gate (330k) -> FBK (100k to VREF)
Daf aux afr daux
Raf1 afr af1 4700
Caf af1 0 4.7e-10
Raf2 af1 0 22000
Dzf qg af1 dzf
.model dzf d(is=1e-12 n=1.5 bv=6.45 ibv=5u rs=100)
Rqg qg 0 1e+06
Cqg qg 0 3.3e-11
Sinv fbk 0 qg 0 swinv
.model swinv sw(vt=1.6 vh=0.05 ron=5 roff=1e9)
Rfbk vref fbk 47000
Cfbk fbk 0 3.3e-11
Vsc scc 0 pwl(0 0 0.0003 0 0.00030005 1)
Ssc out scm scc 0 swsc
.model swsc sw(vt=0.5 vh=0.1 ron=0.02 roff=1e9)
Rscw scm 0 0.03
.ic v(out)=22.7704 v(pol)=22.7704 v(comp)=3.28754 v(k)=20.4328 v(fbs)=2.5 v(vdd)=24.32 v(bulk)=1000 v(rtct)=1 v(ctx)=1 v(af1)=17 v(qg)=10 v(ffm)=22.7704 v(fbk)=0
.options method=gear reltol=1e-3 abstol=1e-9 vntol=1e-5 itl4=100
.tran 20n 0.003 0 20n
.control
run
let pin = -v(hvin)*i(vin)
let pout = v(out)*v(out)/17.283
meas tran vout_avg avg v(out) from=0.0022 to=0.003
meas tran vout_max max v(out) from=0.0022 to=0.003
meas tran vout_min min v(out) from=0.0022 to=0.003
meas tran vds_max max v(drain) from=0.0022 to=0.003
meas tran ipk_max max i(vip) from=0.0022 to=0.003
meas tran pin_avg avg pin from=0.0022 to=0.003
meas tran pout_avg avg pout from=0.0022 to=0.003
meas tran fbk_max max v(fbk) from=0.0022 to=0.003
meas tran comp_avg avg v(comp) from=0.0022 to=0.003
meas tran cs_max max v(cs) from=0.0022 to=0.003
meas tran tper trig v(gate) val=7.5 rise=2 targ v(gate) val=7.5 rise=3 from=0.0022
meas tran ipk_all max i(vip) from=0.0003 to=0.003
meas tran vds_all max v(drain) from=0.0003 to=0.003
meas tran ipk_early max i(vip) from=0.0003 to=0.0006
wrdata /var/folders/zq/839xjjbx6z3c2w55r6gngzv00000gn/T/aux_hv_wave_1000V_short.txt v(drain) i(vip) v(out) v(fbk) v(bulk) v(comp)
quit
.endc
.end
