* PVCELL commutation (double-pulse) test - InventChip IV2Q17040T4Zx2_2L_1100V x2, 1100 V, 72.4 A, L_loop 20.0 nH, R_G 0.7495330067403696 ohm per device. Generated by sim/pv_tradeoff.py
.model dut VDMOS(Vto=3.1 Kp=5 lambda=0.01 Rd=0.02558 Rs=0.5m Rg=2.2 Cgs=3.42e-09 Cgdmax=6.86e-10 Cgdmin=9.75e-12 a=0.01968 Cjo=1.888e-09 Vj=3 M=0.5 Is=7.58e-16 N=3 Rb=0.07054 Tt=0)
Vdc dcp 0 1100.0
Rloop dcp dl 5m
Lloop dl dtop 2e-08
Rdamp dl dtop 10.0
Iload dtop mid 72.44999999999999
.model dsteer D(Is=1e-12 N=0.3)
Rclh0 gh0 ghd 0.6
Rclh1 gh1 ghd 0.6
Mh0 dtop gx0 mid dut
Rgh0 ghd gh0 0.7495330067403696
Ml0 mid gl0 sl dut
Dgon0 gld gn0 dsteer
Rgon0 gn0 gl0 4.497198040442218
Dgof0 gf0 gld dsteer
Rgof0 gl0 gf0 0.7495330067403696
Mh1 dtop gh1 mid dut
Rgh1 ghd gh1 0.7495330067403696
Ml1 mid gl1 sl dut
Dgon1 gld gn1 dsteer
Rgon1 gn1 gl1 4.497198040442218
Dgof1 gf1 gld dsteer
Rgof1 gl1 gf1 0.7495330067403696
Vig0 gh0 gx0 0
Vgh ghd mid -3.5
Vsense sl 0 0
Vgl gld 0 PULSE(-3.5 18.0 1e-07 5e-09 5e-09 1e-06 1)
.save v(mid) v(dtop) v(gh0) i(Vsense) i(Lloop) v(gx0) i(Vig0)
.tran 0.05n 1.7e-06 0 0.05n
.options method=gear maxord=2 reltol=2e-3 abstol=1e-9 gmin=1e-10
.control
run
linearize v(mid) v(dtop) v(gh0) i(Vsense) i(Lloop) v(gx0) i(Vig0)
wrdata pv_dpt_IV2Q17040T4Zx2_2L_1100V.dat v(mid) v(dtop) v(gh0) i(Vsense) i(Lloop) v(gx0) i(Vig0)
quit
.endc
.end
