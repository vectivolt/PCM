* port_precharge.cir - generated by sim/port_design.py (do not edit). Precharge through R_PRE, then the main
* contactor closes when V_term - V_bus = DV_OK. Stiff battery source (worst case for inrush).
.param vbat=1000.0 rs=0.03 ls=3e-06 rpre=220.0 cbus=0.001 esr=0.001 lloop=5e-07 rloop=0.001 cx=2.2e-06 esrx=0.016 tclose=1.0131374409173801
VBAT src 0 DC {vbat}
RS src s1 {rs}
LS s1 term {ls}
CX1 term x1 {cx} IC=1000.0
RX1 x1 0 {esrx}
CX2 term x2 {cx} IC=1000.0
RX2 x2 0 {esrx}
* precharge relay (closes at t = 0) + resistor
SPRE term p1 ctlpre 0 swrel
RPRE p1 bus {rpre}
* main contactor (closes at tclose) + busbar loop
SMAIN term m1 ctlmain 0 swrel
VIK m1 m2 DC 0
LLOOP m2 m3 {lloop}
RLOOP m3 bus {rloop}
* bus capacitor bank
CBUS bus b1 {cbus} IC=0
RESR b1 0 {esr}
VPRE ctlpre 0 PWL(0 0 1u 1)
VMAIN ctlmain 0 PWL(0 0 {tclose} 0 {tclose+1e-6} 1)
.model swrel sw vt=0.5 vh=0.1 ron=1m roff=1e9
.tran 10u 1.01613744091738 0 2u uic
.control
run
wrdata spice_precharge.txt v(bus) i(VIK) v(term)
.endc
.end
