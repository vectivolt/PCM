* PVCELL FSBB switching-level deck 'band': V_A=800 V, V_B=810 V, P=27.5 kW, Sichain SG2M040170HJ x2 per position, f_sw=32.0 kHz, L=233.3 uH. Generated by sim/pv_design.py
.model dut VDMOS(Vto=3.1 Kp=6.961 lambda=0.01 Rd=0.02936 Rs=0.5m Rg=1.4 Cgs=2.589e-09 Cgdmax=5.188e-10 Cgdmin=5e-12 a=0.05444 Cjo=2.098e-09 Vj=3 M=0.5 Is=7.58e-16 N=3 Rb=0.0143 Tt=0)
VA pas 0 800.0
RA pas pa 5m
CA pa ca 9e-05 ic=800.0
RCA ca 0 0.00155
LlA pa ta 2e-08
RdA pa ta 10.0
CB pb cb 9e-05 ic=810.0
RCB cb 0 0.00155
LlB pb tb 2e-08
RdB pb tb 10.0
VSB pb pbr 0
RS pbr pbs 2.0
VB pbs 0 740.941
L1 swa xl 0.0002333377027186508 ic=36.4402
RL xl swb 0.02225
.model dsteer D(Is=1e-12 N=0.3)
MAt0 ta gAt0 swa dut
MAb0 swa gAb0 0 dut
DgAt0n gAtd gAt0n dsteer
RgAt0n gAt0n gAt0 6.779764993698549
DgAt0f gAt0f gAtd dsteer
RgAt0f gAt0 gAt0f 4.5198433291323665
DgAb0n gAbd gAb0n dsteer
RgAb0n gAb0n gAb0 6.779764993698549
DgAb0f gAb0f gAbd dsteer
RgAb0f gAb0 gAb0f 4.5198433291323665
MAt1 ta gAt1 swa dut
MAb1 swa gAb1 0 dut
DgAt1n gAtd gAt1n dsteer
RgAt1n gAt1n gAt1 6.779764993698549
DgAt1f gAt1f gAtd dsteer
RgAt1f gAt1 gAt1f 4.5198433291323665
DgAb1n gAbd gAb1n dsteer
RgAb1n gAb1n gAb1 6.779764993698549
DgAb1f gAb1f gAbd dsteer
RgAb1f gAb1 gAb1f 4.5198433291323665
VgAt gAtd swa PULSE(-3.5 18.0 8.855112e-07 1e-08 1e-08 2.946898e-05 3.125000e-05)
VgAb gAbd 0 PULSE(-3.5 18.0 3.095000e-05 1e-08 1e-08 5.900000e-07 3.125000e-05)
MBt0 tb gBt0 swb dut
MBb0 swb gBb0 0 dut
DgBt0n gBtd gBt0n dsteer
RgBt0n gBt0n gBt0 6.779764993698549
DgBt0f gBt0f gBtd dsteer
RgBt0f gBt0 gBt0f 4.5198433291323665
DgBb0n gBbd gBb0n dsteer
RgBb0n gBb0n gBb0 6.779764993698549
DgBb0f gBb0f gBbd dsteer
RgBb0f gBb0 gBb0f 4.5198433291323665
MBt1 tb gBt1 swb dut
MBb1 swb gBb1 0 dut
DgBt1n gBtd gBt1n dsteer
RgBt1n gBt1n gBt1 6.779764993698549
DgBt1f gBt1f gBtd dsteer
RgBt1f gBt1 gBt1f 4.5198433291323665
DgBb1n gBbd gBb1n dsteer
RgBb1n gBb1n gBb1 6.779764993698549
DgBb1f gBb1f gBbd dsteer
RgBb1f gBb1 gBb1f 4.5198433291323665
VgBt gBtd swb PULSE(-3.5 18.0 1.652991e-06 1e-08 1e-08 2.793402e-05 3.125000e-05)
VgBb gBbd 0 PULSE(-3.5 18.0 3.018252e-05 1e-08 1e-08 2.124960e-06 3.125000e-05)
.save i(L1) v(swa) v(swb) v(ta) v(tb) v(pa) v(pb) i(VA) i(VSB)
.tran 1n 9.375000e-04 8.750000e-04 2n uic
.options method=gear
.control
run
linearize i(L1) v(swa) v(swb) v(ta) v(tb) v(pa) v(pb) i(VA) i(VSB)
wrdata pv_fsbb_band.dat i(L1) v(swa) v(swb) v(ta) v(tb) v(pa) v(pb) i(VA) i(VSB)
quit
.endc
.end
