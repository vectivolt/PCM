* PCS-P125 two-level leg commutation - Sichain SG2M040170HJ x6 per switch, 1050 V, 450 A, physical leg (bus 7.5 nH, decoupling 19.8 uF, board 5.75 nH, damper 3.33 ohm + 7.0 nF), R_G,eff 4.52 ohm per device. Generated by sim/pcs_design.py (step e)
.model dut VDMOS(Vto=3.1 Kp=6.961 lambda=0.01 Rd=0.02936 Rs=0.5m Rg=1.4 Cgs=2.589e-09 Cgdmax=5.188e-10 Cgdmin=5e-12 a=0.05444 Cjo=2.098e-09 Vj=3 M=0.5 Is=7.58e-16 N=3 Rb=0.0143 Tt=0)
Vdc dcp 0 1050.0
Rsrc dcp bk 50m
Cbk bk bk1 0.00035
Lbk bk1 bk2 2.1e-08
Rbk bk2 0 0.0012000000000000001
Lbus bk lb 7.5e-09
Cdc lb dc1 1.98e-05
Ldc dc1 dc2 2.7777777777777776e-09
Rdc dc2 0 0.0025
Lloop lb dtop 5.75e-09
Rdmp dtop dm 3.3266666666666667
Cdmp dm 0 7.05e-09
Rdmpx dm 0 1e8
Rbusd bk lb 10.0
Rlpd lb dtop 10.0
Iload dtop mid 450.0
Rclh0 gh0 ghd 0.6
Rclh1 gh1 ghd 0.6
Rclh2 gh2 ghd 0.6
Rclh3 gh3 ghd 0.6
Rclh4 gh4 ghd 0.6
Rclh5 gh5 ghd 0.6
Mh0 dtop gh0 mid dut
Rgh0 ghd gh0 4.5198433291323665
Ml0 mid gl0 sl dut
Rgl0 gld gl0 4.5198433291323665
Mh1 dtop gh1 mid dut
Rgh1 ghd gh1 4.5198433291323665
Ml1 mid gl1 sl dut
Rgl1 gld gl1 4.5198433291323665
Mh2 dtop gh2 mid dut
Rgh2 ghd gh2 4.5198433291323665
Ml2 mid gl2 sl dut
Rgl2 gld gl2 4.5198433291323665
Mh3 dtop gh3 mid dut
Rgh3 ghd gh3 4.5198433291323665
Ml3 mid gl3 sl dut
Rgl3 gld gl3 4.5198433291323665
Mh4 dtop gh4 mid dut
Rgh4 ghd gh4 4.5198433291323665
Ml4 mid gl4 sl dut
Rgl4 gld gl4 4.5198433291323665
Mh5 dtop gh5 mid dut
Rgh5 ghd gh5 4.5198433291323665
Ml5 mid gl5 sl dut
Rgl5 gld gl5 4.5198433291323665
Vgh ghd mid -3.5
Vsense sl 0 0
Vgl gld 0 PULSE(-3.5 18.0 1e-07 5e-09 5e-09 1e-06 1)
.save v(mid) v(dtop) i(Vsense) i(Lloop)
.tran 0.05n 1.7e-06 0 0.05n
.options method=gear maxord=2 reltol=2e-3 abstol=1e-9
.control
run
linearize v(mid) v(dtop) i(Vsense) i(Lloop)
wrdata pcs_commutation_sweep0.dat v(mid) v(dtop) i(Vsense) i(Lloop)
quit
.endc
.end
