* PVCELL gate network check (own) - Sichain x2, 1000 V, 2.0 A, R_KS 0.5 ohm. Generated by sim/pv_tradeoff.py gate_deck()
.model dut VDMOS(Vto=3.1 Kp=6.961 lambda=0.01 Rd=0.02936 Rs=0.5m Rg=1.4 Cgs=2.589e-09 Cgdmax=5.188e-10 Cgdmin=5e-12 a=0.05444 Cjo=2.098e-09 Vj=3 M=0.5 Is=7.58e-16 N=3 Rb=0.0143 Tt=0)
Vdc dcp 0 1000.0
Rsrc dcp bk 50m
Cbk bk bk1 9e-05
Lbk bk1 bk2 9.5e-09
Rbk bk2 0 0.00155
Lbus bk lb 1.5e-08
Cdc lb dc1 6.6e-06
Ldc dc1 dc2 8e-09
Rdc dc2 0 0.005333333333333333
Lloop lb dtop 1.15e-08
Rdmp dtop dm 9.98
Cdmp dm 0 2.35e-09
Rdmpx dm 0 1e8
.model zxtp PNP(IS=1.74e-13 BF=30 BR=10 RB=0.5 RE=0.02 RC=0.04 CJE=150p CJC=50p VJC=0.75 MJC=0.4 TF=0.59n VAF=100)
.model dpmeg D(Is=6.2e-8 N=1 Rs=0.14 Cjo=77p Vj=0.4 M=0.4)
.model dsteer D(Is=1e-12 N=0.3)
.model dz22 D(Is=1e-14 BV=21.0 IBV=5m Rs=1)
.model dz56 D(Is=1e-14 BV=4.9 IBV=5m Rs=2)
.model swcl SW(Vt=0.5 Vh=0.05 Ron=0.6 Roff=1e9)
Vsense sl 0 0
Rksl kl sl 0.25
Vel vel kl -3.5
Rksh kh mid 0.25
Iload dtop mid 2.0
Vgl gld kl PULSE(-3.5 18.0 1e-07 5e-09 5e-09 1e-06 1)
Dgon gld outh dsteer
Dgof outl gld dsteer
Rpu outh cll 150.0
Scl cll vel ctld 0 swcl
Bct ctl 0 V=u(-v(gld,kl))*u(2.0-v(cll,vel))
Rct ctl ctld 1k
Cct ctld 0 50p
Dct ctld ctl dsteer
Vgh ghd kh -3.5
Vsh dtop dth 0
Ml0 mid gxl0 sl dut
Mh0 dth gh0 mid dut
Dpm0 cll gl0 dpmeg
Q0 qc0 cll gl0 zxtp temp=-30.0
Cvl0 vl0 sl 1e-06
Rvl0 vel vl0 4.7
Rgs0 gl0 sl 10k
Dzp0 zm0 gl0 dz22
Dzn0 zm0 sl dz56
Rgon0 outh gl0 6.779764993698549
Rgof0 gl0 outl 4.5198433291323665
Rgh0 ghd gh0 4.5198433291323665
Rclh0 gh0 ghd 0.6
Ml1 mid gl1 sl dut
Mh1 dth gh1 mid dut
Dpm1 cll gl1 dpmeg
Q1 vl1 cll gl1 zxtp temp=-30.0
Cvl1 vl1 sl 1e-06
Rvl1 vel vl1 4.7
Rgs1 gl1 sl 10k
Dzp1 zm1 gl1 dz22
Dzn1 zm1 sl dz56
Rgon1 outh gl1 6.779764993698549
Rgof1 gl1 outl 4.5198433291323665
Rgh1 ghd gh1 4.5198433291323665
Rclh1 gh1 ghd 0.6
Vig0 gl0 gxl0 0
Vq0 qc0 vl0 0
.save v(mid) v(dtop) v(gl0) v(gxl0) i(Vig0) i(Vq0) v(vl0) i(Vsense) i(Vsh) v(ctld)
.tran 0.05n 1.7e-06 0 0.05n
.options method=gear maxord=2 reltol=5e-3 abstol=1e-8
.control
run
linearize v(mid) v(dtop) v(gl0) v(gxl0) i(Vig0) i(Vq0) v(vl0) i(Vsense) i(Vsh) v(ctld)
wrdata pv_dpt_gate_own.dat v(mid) v(dtop) v(gl0) v(gxl0) i(Vig0) i(Vq0) v(vl0) i(Vsense) i(Vsh) v(ctld)
quit
.endc
.end
